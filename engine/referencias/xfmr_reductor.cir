* Transformador (dos inductores acoplados): xfmr_reductor
V1 1 0 SIN(0 10 60)
R1 1 2 10
L1 2 0 1
L2 3 0 0.0625
K1 L1 L2 0.98
R2 3 0 100
.options reltol=1e-4 abstol=1e-12 vntol=1e-7
.control
set wr_singlescale
set wr_vecnames
option numdgt=7
tran 20u 0.05 0 20u uic
wrdata salida.txt v(2) v(3) i(v1)
.endc
.end
