* DAC0808 en corriente (figura 1 de la hoja): VREF de 10 V sobre R14 de 5 kohm, R15 igual a tierra y carga de 1 kohm en IO
.model adc_0 adc_bridge(in_low=0.8 in_high=2 rise_delay=1e-12 fall_delay=1e-12)
.model da_0 dac_bridge(out_low=0 out_high=1 out_undef=0.5 t_rise=1.5e-7 t_fall=1.5e-7)
V1 vee 0 DC -15
V2 vref 0 DC 10
R1 vref refp 5k
R2 refn 0 5k
RL io 0 1k
VB0 b0 0 PWL(0 0 0.000004 0 0.0000040009999999999995 5 0.000008 5 0.000008001 0 0.000011999999999999999 0 0.000012000999999999999 5 0.000014 5 0.000014001 0 0.000018 0 0.000018001 5 0.000022 5 0.000022000999999999998 0 0.000024 0 0.000024001 5 0.000026000000000000002 5 0.000026001 0 0.000028 0 0.000028001 5 0.00003 5 0.000030001 0 0.000032 0 0.000032001 5 0.000034 5 0.000034001 0 0.000038 0 0.000038001000000000004 5 0.000039999999999999996 5 0.000040001 0)
VB1 b1 0 PWL(0 0 0.000004 0 0.0000040009999999999995 5 0.000006 5 0.000006001 0 0.000008 0 0.000008001 5 0.000009999999999999999 5 0.000010001 0 0.000014 0 0.000014001 5 0.000018 5 0.000018001 0 0.00002 0 0.000020001 5 0.000022 5 0.000022000999999999998 0 0.000024 0 0.000024001 5 0.000026000000000000002 5 0.000026001 0 0.000028 0 0.000028001 5 0.00003 5 0.000030001 0 0.000032 0 0.000032001 5 0.000036 5 0.000036001 0 0.000038 0 0.000038001000000000004 5)
VB2 b2 0 PWL(0 0 0.000004 0 0.0000040009999999999995 5 0.000006 5 0.000006001 0 0.000011999999999999999 0 0.000012000999999999999 5 0.000014 5 0.000014001 0 0.000016 0 0.000016000999999999998 5 0.000018 5 0.000018001 0 0.000022 0 0.000022000999999999998 5 0.000026000000000000002 5 0.000026001 0 0.000032 0 0.000032001 5 0.000038 5 0.000038001000000000004 0)
VB3 b3 0 PWL(0 0 0.000004 0 0.0000040009999999999995 5 0.000006 5 0.000006001 0 0.000014 0 0.000014001 5 0.000018 5 0.000018001 0 0.000024 0 0.000024001 5 0.000026000000000000002 5 0.000026001 0 0.000032 0 0.000032001 5 0.000034 5 0.000034001 0 0.000036 0 0.000036001 5 0.000038 5 0.000038001000000000004 0)
VB4 b4 0 PWL(0 0 0.000004 0 0.0000040009999999999995 5 0.000006 5 0.000006001 0 0.000011999999999999999 0 0.000012000999999999999 5 0.000014 5 0.000014001 0 0.000016 0 0.000016000999999999998 5 0.000018 5 0.000018001 0 0.00002 0 0.000020001 5 0.000022 5 0.000022000999999999998 0 0.000024 0 0.000024001 5 0.000026000000000000002 5 0.000026001 0 0.00003 0 0.000030001 5 0.000032 5 0.000032001 0 0.000038 0 0.000038001000000000004 5)
VB5 b5 0 PWL(0 0 0.000004 0 0.0000040009999999999995 5 0.000006 5 0.000006001 0 0.000014 0 0.000014001 5 0.000018 5 0.000018001 0 0.000024 0 0.000024001 5 0.000026000000000000002 5 0.000026001 0 0.00003 0 0.000030001 5 0.000032 5 0.000032001 0 0.000034 0 0.000034001 5 0.000036 5 0.000036001 0 0.000038 0 0.000038001000000000004 5)
VB6 b6 0 PWL(0 0 0.000004 0 0.0000040009999999999995 5 0.000006 5 0.000006001 0 0.000011999999999999999 0 0.000012000999999999999 5 0.000014 5 0.000014001 0 0.000016 0 0.000016000999999999998 5 0.000018 5 0.000018001 0 0.000024 0 0.000024001 5 0.000028 5 0.000028001 0 0.00003 0 0.000030001 5 0.000032 5 0.000032001 0 0.000036 0 0.000036001 5 0.000038 5 0.000038001000000000004 0)
VB7 b7 0 PWL(0 0 0.000004 0 0.0000040009999999999995 5 0.000006 5 0.000006001 0 0.000009999999999999999 0 0.000010001 5 0.000011999999999999999 5 0.000012000999999999999 0 0.000014 0 0.000014001 5 0.00002 5 0.000020001 0 0.000022 0 0.000022000999999999998 5 0.000024 5 0.000024001 0 0.00003 0 0.000030001 5 0.000032 5 0.000032001 0 0.000036 0 0.000036001 5 0.000038 5 0.000038001000000000004 0 0.000039999999999999996 0 0.000040001 5)
AIN0 [b0] [d0] adc_0
AIN1 [b1] [d1] adc_0
AIN2 [b2] [d2] adc_0
AIN3 [b3] [d3] adc_0
AIN4 [b4] [d4] adc_0
AIN5 [b5] [d5] adc_0
AIN6 [b6] [d6] adc_0
AIN7 [b7] [d7] adc_0
a0d0 [d0] [kb0x0] da_0
rk0x0 kb0x0 0 1g
a0d1 [d1] [kb0x1] da_0
rk0x1 kb0x1 0 1g
a0d2 [d2] [kb0x2] da_0
rk0x2 kb0x2 0 1g
a0d3 [d3] [kb0x3] da_0
rk0x3 kb0x3 0 1g
a0d4 [d4] [kb0x4] da_0
rk0x4 kb0x4 0 1g
a0d5 [d5] [kb0x5] da_0
rk0x5 kb0x5 0 1g
a0d6 [d6] [kb0x6] da_0
rk0x6 kb0x6 0 1g
a0d7 [d7] [kb0x7] da_0
rk0x7 kb0x7 0 1g
E1 x vee refn vee 1
vz0 refp x dc 0
bz0 io vee i=(v(kb0x0)*0.5+v(kb0x1)*0.25+v(kb0x2)*0.125+v(kb0x3)*0.0625+v(kb0x4)*0.03125+v(kb0x5)*0.015625+v(kb0x6)*0.0078125+v(kb0x7)*0.00390625)*i(vz0)
.options reltol=1e-4 abstol=1e-12 vntol=1e-7 xtrtol=7
.control
set wr_singlescale
set wr_vecnames
option numdgt=7
tran 1n 0.000042 0 1n uic
wrdata salida.txt v(io)
.endc
.end
