* PNP 2N5401 con unos 10 mA
.include modelos.lib
V1 1 0 DC 12
RB 2 0 160k
RC 3 0 470
Q1 3 2 1 Q2N5401
.options reltol=1e-4 abstol=1e-12 vntol=1e-7
.control
set wr_singlescale
set wr_vecnames
option numdgt=7
op
wrdata salida.txt v(2) v(3) i(v1)
.endc
.end
