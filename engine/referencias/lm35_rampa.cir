* LM35 con la temperatura de 0 a 100 C entre 0 y 2 ms (el seguidor del motor la sigue) y de vuelta entre 8 y 10 ms
VT tsens 0 PWL(0m 0 2m 1 8m 1 10m 0)
.include modelos.lib
V1 vcc 0 DC 5
RL out 0 10k
XU1 tsens out out vcc 0 AMPOP a0=100000 gbw=1000000 sr=1000000 rin=1000000000000 rout=0.5 ilim=0.01 dhi=1.5 dlo=0.01 rq=89286
.options reltol=1e-4 abstol=1e-12 vntol=1e-7
.control
set wr_singlescale
set wr_vecnames
option numdgt=7
tran 5u 10m 0 5u uic
wrdata salida.txt v(out) i(v1)
.endc
.end
