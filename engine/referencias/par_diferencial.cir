* Par diferencial con dos 2N3904 y resistencia de cola
.include modelos.lib
V1 1 0 DC 12
V2 7 0 DC -12
VIN 2 0 SIN(0 10m 1k)
RC1 1 3 10k
RC2 1 4 10k
Q1 3 2 5 Q2N3904
Q2 4 0 5 Q2N3904
RT 5 7 11k
.options reltol=1e-4 abstol=1e-12 vntol=1e-7
.control
set wr_singlescale
set wr_vecnames
option numdgt=7
tran 5u 3m 0 1u uic
wrdata salida.txt v(3) v(4) v(5)
.endc
.end
