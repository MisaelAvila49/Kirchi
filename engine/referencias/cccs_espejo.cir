* Fuente de corriente controlada por corriente de ganancia 0.5 que refleja la corriente de una rama
V1 1 0 DC 5
R1 1 2 1k
VF1_CTL 2 0 DC 0
F1 4 0 VF1_CTL 0.5
V2 3 0 DC 5
RL 3 4 1k
.options reltol=1e-4 abstol=1e-12 vntol=1e-7
.control
set wr_singlescale
set wr_vecnames
option numdgt=7
op
wrdata salida.txt v(2) v(4) i(v1) i(v2)
.endc
.end
