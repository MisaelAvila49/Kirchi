* Limitador de arranque SCK08053 con 3 V y 1 Ohm: la corriente sube de 0.5 A a unos 2.1 A al calentarse
*@generar termistor tm1 {"tipo":"ntc","r25":5,"beta":2668,"delta":0.016,"tau":38}
V1 1 0 DC 3
R1 1 2 1
X1 2 0 tm1 amb=25
.options reltol=1e-4 abstol=1e-12 vntol=1e-7
.control
set wr_singlescale
set wr_vecnames
option numdgt=7
tran 0.5 200 0 0.2 uic
wrdata salida.txt v(2) i(v1)
.endc
.end
