* Arranque de un motor DC de 6 V
.include modelos.lib
V1 1 0 DC 6
RM 1 2 3
LM 2 3 1.5m
VS 3 4 DC 0
BE 4 0 V=6.05e-3*V(w)
BT 0 w I=6.05e-3*I(VS)
CJ w 0 2.4e-7
RB w 0 {1/6.4e-7}
.options reltol=1e-4 abstol=1e-12 vntol=1e-7
.control
set wr_singlescale
set wr_vecnames
option numdgt=7
tran 50u 150m 0 10u uic
wrdata salida.txt i(v1) v(w)
.endc
.end
