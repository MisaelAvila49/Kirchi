* FGA25N120ANTD con 200 V y 6 ohm en el colector y 8.4 V en la compuerta: zona activa
.include modelos.lib
V1 vin 0 DC 200
R1 vin c 6
V2 g 0 DC 8.4
M1 b g 0 0 MIGBT2 W=1 L=1
Q1 0 b ce QIGBT2
RE c ce 0.007178
D1 0 c DIGBT2
CGE g 0 3.62n
CGC g c 80p
CCE c 0 50p
.options reltol=1e-4 abstol=1e-12 vntol=1e-7
.control
set wr_singlescale
set wr_vecnames
option numdgt=7
op
wrdata salida.txt v(c) i(v1)
.endc
.end
