* IRG4BC30UD con -5 V y 0.5 ohm en el colector: conduce el diodo en antiparalelo
.include modelos.lib
V1 vin 0 DC -5
R1 vin c 0.5
V2 g 0 DC 0
M1 b g 0 0 MIGBT1 W=1 L=1
Q1 0 b ce QIGBT1
RE c ce 0.016174
D1 0 c DIGBT1
CGE g 0 1.086n
CGC g c 14p
CCE c 0 59p
.options reltol=1e-4 abstol=1e-12 vntol=1e-7
.control
set wr_singlescale
set wr_vecnames
option numdgt=7
op
wrdata salida.txt v(c) i(v1)
.endc
.end
