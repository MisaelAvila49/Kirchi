* Registro 74HC164 a 4.5 V con A, B y CLR al azar
.model adc_0 adc_bridge(in_low=1.3499999999999999 in_high=3.15 rise_delay=1e-12 fall_delay=1e-12)
V1 n1 0 PWL(0 4.5 0.00000385 4.5 0.0000038500001 0 0.00000685 0 0.0000068500001 4.5 0.00000785 4.5 0.000007850000100000001 0 0.00000885 0 0.0000088500001 4.5 0.00001185 4.5 0.0000118500001 0 0.00001585 0 0.0000158500001 4.5 0.00001991 4.5 0.000019910000100000002 0 0.00002585 0 0.0000258500001 4.5 0.00002885 4.5 0.0000288500001 0 0.00003185 0 0.0000318500001 4.5 0.00003485 4.5 0.0000348500001 0 0.00003885 0 0.0000388500001 4.5 0.00003991 4.5 0.0000399100001 0 0.00004191 0 0.000041910000099999995 4.5 0.00004285 4.5 0.000042850000099999996 0 0.00004385 0 0.0000438500001 4.5 0.00004485 4.5 0.0000448500001 0 0.00004585 0 0.000045850000099999995 4.5 0.00004991 4.5 0.0000499100001 0 0.00005285 0 0.000052850000099999995 4.5 0.00005591 4.5 0.000055910000099999997 0 0.00005785 0 0.000057850000099999995 4.5 0.00006185 4.5 0.0000618500001 0)
V2 n2 0 PWL(0 4.5 8.5e-7 4.5 8.500001e-7 0 0.00000585 0 0.0000058500001 4.5 0.00000891 4.5 0.0000089100001 0 0.00001985 0 0.0000198500001 4.5 0.00002785 4.5 0.0000278500001 0 0.00002891 0 0.0000289100001 4.5 0.00003285 4.5 0.0000328500001 0 0.00003585 0 0.000035850000099999996 4.5 0.00003891 4.5 0.0000389100001 0 0.00003985 0 0.0000398500001 4.5 0.00004185 4.5 0.0000418500001 0 0.00004491 0 0.0000449100001 4.5 0.00004685 4.5 0.0000468500001 0 0.00004785 0 0.000047850000099999996 4.5 0.00004985 4.5 0.0000498500001 0 0.00005085 0 0.000050850000099999994 4.5 0.00005585 4.5 0.0000558500001 0 0.00005685 0 0.0000568500001 4.5 0.00005791 4.5 0.0000579100001 0 0.00005885 0 0.0000588500001 4.5 0.00006285 4.5 0.0000628500001 0)
V3 n3 0 PWL(0 0 8.5e-7 0 8.500001e-7 4.5 0.00006191 4.5 0.0000619100001 0 0.00006291 0 0.0000629100001 4.5)
V4 n4 0 PWL(0 0 3e-7 0 3.000001e-7 4.5 8e-7 4.5 8.000001e-7 0 0.0000013 0 0.0000013000001 4.5 0.0000018 4.5 0.0000018000001 0 0.0000023 0 0.0000023000001000000004 4.5 0.0000028 4.5 0.0000028000001000000002 0 0.0000033 0 0.0000033000001 4.5 0.0000038 4.5 0.0000038000001000000004 0 0.0000043 0 0.0000043000001 4.5 0.0000048 4.5 0.0000048000001000000006 0 0.0000053 0 0.0000053000001 4.5 0.0000058 4.5 0.0000058000001 0 0.0000063 0 0.000006300000100000001 4.5 0.0000068 4.5 0.0000068000001 0 0.0000073 0 0.0000073000001 4.5 0.0000078 4.5 0.0000078000001 0 0.0000083 0 0.0000083000001 4.5 0.0000088 4.5 0.000008800000099999999 0 0.0000093 0 0.000009300000099999999 4.5 0.0000098 4.5 0.0000098000001 0 0.0000103 0 0.0000103000001 4.5 0.0000108 4.5 0.0000108000001 0 0.0000113 0 0.000011300000099999998 4.5 0.0000118 4.5 0.000011800000099999999 0 0.0000123 0 0.000012300000099999999 4.5 0.0000128 4.5 0.0000128000001 0 0.0000133 0 0.0000133000001 4.5 0.0000138 4.5 0.0000138000001 0 0.0000143 0 0.000014300000099999999 4.5 0.0000148 4.5 0.000014800000099999999 0 0.0000153 0 0.0000153000001 4.5 0.0000158 4.5 0.0000158000001 0 0.0000163 0 0.000016300000099999998 4.5 0.0000168 4.5 0.0000168000001 0 0.0000173 0 0.000017300000100000002 4.5 0.0000178 4.5 0.0000178000001 0 0.0000183 0 0.000018300000100000003 4.5 0.0000188 4.5 0.0000188000001 0 0.0000193 0 0.0000193000001 4.5 0.0000198 4.5 0.000019800000100000002 0 0.0000203 0 0.0000203000001 4.5 0.0000208 4.5 0.000020800000100000002 0 0.0000213 0 0.0000213000001 4.5 0.0000218 4.5 0.0000218000001 0 0.0000223 0 0.0000223000001 4.5 0.0000228 4.5 0.0000228000001 0 0.0000233 0 0.000023300000100000002 4.5 0.0000238 4.5 0.0000238000001 0 0.0000243 0 0.000024300000100000003 4.5 0.0000248 4.5 0.0000248000001 0 0.0000253 0 0.0000253000001 4.5 0.0000258 4.5 0.000025800000100000002 0 0.0000263 0 0.0000263000001 4.5 0.0000268 4.5 0.000026800000100000003 0 0.0000273 0 0.0000273000001 4.5 0.0000278 4.5 0.0000278000001 0 0.0000283 0 0.000028300000100000002 4.5 0.0000288 4.5 0.0000288000001 0 0.0000293 0 0.000029300000100000002 4.5 0.0000298 4.5 0.0000298000001 0 0.0000303 0 0.0000303000001 4.5 0.0000308 4.5 0.0000308000001 0 0.0000313 0 0.0000313000001 4.5 0.0000318 4.5 0.0000318000001 0 0.0000323 0 0.000032300000100000004 4.5 0.0000328 4.5 0.000032800000099999996 0 0.0000333 0 0.000033300000099999995 4.5 0.0000338 4.5 0.0000338000001 0 0.0000343 0 0.0000343000001 4.5 0.0000348 4.5 0.0000348000001 0 0.0000353 0 0.000035300000099999996 4.5 0.0000358 4.5 0.000035800000099999994 0 0.0000363 0 0.0000363000001 4.5 0.0000368 4.5 0.0000368000001 0 0.0000373 0 0.0000373000001 4.5 0.0000378 4.5 0.000037800000099999995 0 0.0000383 0 0.0000383000001 4.5 0.0000388 4.5 0.0000388000001 0 0.0000393 0 0.0000393000001 4.5 0.0000398 4.5 0.0000398000001 0 0.0000403 0 0.000040300000099999995 4.5 0.0000408 4.5 0.0000408000001 0 0.0000413 0 0.0000413000001 4.5 0.0000418 4.5 0.0000418000001 0 0.0000423 0 0.000042300000099999996 4.5 0.0000428 4.5 0.000042800000099999995 0 0.0000433 0 0.0000433000001 4.5 0.0000438 4.5 0.0000438000001 0 0.0000443 0 0.0000443000001 4.5 0.0000448 4.5 0.000044800000099999996 0 0.0000453 0 0.000045300000099999995 4.5 0.0000458 4.5 0.0000458000001 0 0.0000463 0 0.0000463000001 4.5 0.0000468 4.5 0.0000468000001 0 0.0000473 0 0.000047300000099999996 4.5 0.0000478 4.5 0.000047800000099999995 0 0.0000483 0 0.0000483000001 4.5 0.0000488 4.5 0.0000488000001 0 0.0000493 0 0.0000493000001 4.5 0.0000498 4.5 0.000049800000099999996 0 0.0000503 0 0.000050300000099999994 4.5 0.0000508 4.5 0.0000508000001 0 0.0000513 0 0.0000513000001 4.5 0.0000518 4.5 0.0000518000001 0 0.0000523 0 0.000052300000099999996 4.5 0.0000528 4.5 0.000052800000099999994 0 0.0000533 0 0.0000533000001 4.5 0.0000538 4.5 0.0000538000001 0 0.0000543 0 0.0000543000001 4.5 0.0000548 4.5 0.000054800000099999995 0 0.0000553 0 0.0000553000001 4.5 0.0000558 4.5 0.0000558000001 0 0.0000563 0 0.0000563000001 4.5 0.0000568 4.5 0.000056800000099999997 0 0.0000573 0 0.000057300000099999995 4.5 0.0000578 4.5 0.0000578000001 0 0.0000583 0 0.0000583000001 4.5 0.0000588 4.5 0.0000588000001 0 0.0000593 0 0.000059300000099999996 4.5 0.0000598 4.5 0.000059800000099999995 0 0.0000603 0 0.0000603000001 4.5 0.0000608 4.5 0.0000608000001 0 0.0000613 0 0.00006130000009999999 4.5 0.0000618 4.5 0.0000618000001 0 0.0000623 0 0.0000623000001 4.5 0.0000628 4.5 0.0000628000001 0 0.0000633 0 0.0000633000001 4.5 0.0000638 4.5 0.0000638000001 0)
AIN0 [n4] [d8] adc_0
AIN1 [n1] [d9] adc_0
AIN2 [n2] [d10] adc_0
AIN3 [n3] [d11] adc_0
*@generar msi u0 {"entradas":["d8","d9","d10","d11"],"salidas":["d0","d1","d2","d3","d4","d5","d6","d7"],"nucleo":{"tipo":"desplazamiento","bits":8,"reloj":{"senales":[{"entrada":0}],"flanco":"subida"},"serie":[{"entrada":1},{"entrada":2}],"borra":{"senal":{"entrada":3,"bajo":true},"sincrona":false}},"de":[{"tipo":"directa","fuente":{"bit":0}},{"tipo":"directa","fuente":{"bit":1}},{"tipo":"directa","fuente":{"bit":2}},{"tipo":"directa","fuente":{"bit":3}},{"tipo":"directa","fuente":{"bit":4}},{"tipo":"directa","fuente":{"bit":5}},{"tipo":"directa","fuente":{"bit":6}},{"tipo":"directa","fuente":{"bit":7}}],"retardos":[[1.9500000000000003e-8,1.9500000000000003e-8],[1.9500000000000003e-8,1.9500000000000003e-8],[1.9500000000000003e-8,1.9500000000000003e-8],[1.9500000000000003e-8,1.9500000000000003e-8],[1.9500000000000003e-8,1.9500000000000003e-8],[1.9500000000000003e-8,1.9500000000000003e-8],[1.9500000000000003e-8,1.9500000000000003e-8],[1.9500000000000003e-8,1.9500000000000003e-8]]}
.options reltol=1e-4 abstol=1e-12 vntol=1e-7 xtrtol=7
.control
set wr_singlescale
set wr_vecnames
option numdgt=7
tran 1n 64000n 0 0.1n uic
wrdata salida.txt v(n1)
eprint d0 d1 d2 d3 d4 d5 d6 d7 > eventos.txt
.endc
.end
