* TL431 con K unido a REF y 10 mA: la referencia de 2.495 V de la hoja
.include modelos.lib
V1 vcc 0 DC 12
R1 vcc k 950
XU1 k vr g k ae AMPOP a0=20000 gbw=500000000 sr=1000000000 rin=1000000000000 rout=500 ilim=0.005 dhi=0.8 dlo=0.01 rq=1000000000000
VREF vr ae DC 2.493
Q1 k g ae QTL431
RS ae 0 0.2
D1 0 k DTL431
RREF k 0 1250000
.options reltol=1e-4 abstol=1e-12 vntol=1e-7 method=gear
.control
set wr_singlescale
set wr_vecnames
option numdgt=7
op
wrdata salida.txt v(k) i(v1)
.endc
.end
