* L298 a 9 V con un motor DC de 6 V entre OUT1 y OUT2, cuatro 1N4007 de rueda libre y la habilitación A en alto: frena en bajo, gira hacia un lado, frena, gira hacia el otro y frena en alto
.include modelos.lib
.model adc_l298 adc_bridge(in_low=1.9 in_high=1.9 rise_delay=1e-12 fall_delay=1e-12)
.model ts_l298 d_tristate(delay=1.75e-6)
.model dac_l298 dac_bridge(out_low=0 out_high=1 out_undef=0.5 t_rise=0.7e-6 t_fall=0.25e-6)
V1 vs 0 DC 9
V2 vss 0 DC 5
RVSS vss 0 208.33333
V3 ena 0 DC 5
V4 in1 0 PWL(0 0 2m 0 2.001m 5 6m 5 6.001m 0 13m 0 13.001m 5 15m 5 15.001m 0 18m 0)
V5 in2 0 PWL(0 0 9m 0 9.001m 5 15m 5 15.001m 0 18m 0)
* Entradas: umbral de 1.9 V y 150 kOhm a tierra
RIE ena xe 150k
VIE xe 0 DC 0
AE [ena] [de] adc_l298
RI1 in1 x1 150k
VI1 x1 0 DC 0
A1 [in1] [d1] adc_l298
RI2 in2 x2 150k
VI2 x2 0 DC 0
A2 [in2] [d2] adc_l298
* Cada semipuente: compuerta con habilitacion y fuente de Thevenin entre SENSE (tierra) y VS
AT1 d1 de f1 ts_l298
AT2 d2 de f2 ts_l298
AD1 [f1] [oc1] dac_l298
ROC1 oc1 0 1g
BO1 o1 0 i=(v(o1)-(0.7*(1-v(oc1))+(v(vs)-0.7)*v(oc1)))/(0.5*(1-v(oc1))+0.65*v(oc1))
AD2 [f2] [oc2] dac_l298
ROC2 oc2 0 1g
BO2 o2 0 i=(v(o2)-(0.7*(1-v(oc2))+(v(vs)-0.7)*v(oc2)))/(0.5*(1-v(oc2))+0.65*v(oc2))
* Motor DC de 6 V
RM o1 m1 3
LM m1 m2 1.5m
VM m2 m3 DC 0
BE m3 o2 V=6.05e-3*V(w)
BT 0 w I=6.05e-3*I(VM)
CJ w 0 2.4e-7
RB w 0 {1/6.4e-7}
D1 o1 vs D1N4007
D2 o2 vs D1N4007
D3 0 o1 D1N4007
D4 0 o2 D1N4007
.options reltol=1e-4 abstol=1e-12 vntol=1e-7 xtrtol=7
.control
set wr_singlescale
set wr_vecnames
option numdgt=7
tran 1u 18m 0 1u uic
wrdata salida.txt v(o1) v(o2) i(vm) v(w)
.endc
.end
