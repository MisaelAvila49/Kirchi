* Regulador con zener 1N4761A de 75 V (3.3 mA, 175 ohm)
.include modelos.lib
V1 1 0 DC 100
R1 1 2 2.2k
D1 0 2 D1N4761A
RL 2 0 10k
.options reltol=1e-4 abstol=1e-12 vntol=1e-7
.control
set wr_singlescale
set wr_vecnames
option numdgt=7
op
wrdata salida.txt v(2) i(v1)
.endc
.end
