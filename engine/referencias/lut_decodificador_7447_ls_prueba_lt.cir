* Decodificador 74LS47 a 5 V con la prueba de segmentos LT en pulso y RBI en alto; BI/RBO al aire
.model adc_0 adc_bridge(in_low=0.8 in_high=2 rise_delay=1e-12 fall_delay=1e-12)
.model uno_d d_pullup(load=1e-12)
V1 n1 0 PULSE(0 5 1e-7 1e-12 1e-12 9.99999e-7 0.000002)
V2 n2 0 PULSE(0 5 3.18e-7 1e-12 1e-12 0.000001999999 0.000004)
V3 n3 0 PULSE(0 5 5.36e-7 1e-12 1e-12 0.000003999999 0.000008)
V4 n4 0 PULSE(0 5 7.54e-7 1e-12 1e-12 0.000007999999 0.000016)
V5 n5 0 PULSE(0 5 0.000001753 1e-12 1e-12 0.000002999999 0.000005999999999987999)
V6 n6 0 DC 5
AIN0 [n5] [d8] adc_0
AIN1 [n6] [d9] adc_0
AIN2 [n4] [d10] adc_0
AIN3 [n3] [d11] adc_0
AIN4 [n2] [d12] adc_0
AIN5 [n1] [d13] adc_0
*@generar lut u0 {"comunes":["d8","d9","d0","d10","d11","d12","d13"],"rebanadas":[{"entradas":[],"salidas":["d1","d2","d3","d4","d5","d6","d7","d0"]}],"tabla":[21845,21845,21845,21845,21845,21845,21845,21845,21845,21845,21845,21845,21845,21845,21845,21845,16384,16384,16384,16384,16384,16384,16384,16384,16384,16384,16384,16384,16384,16384,16384,16384,21845,21845,21845,21845,21845,21845,21845,21845,21845,21845,21845,21845,21845,21845,21845,21845,16384,16384,16384,16384,16384,16384,16384,16384,16384,16384,16384,16384,16384,16384,16384,16384,5461,21845,21845,21845,21845,21845,21845,21845,21845,21845,21845,21845,21845,21845,21845,21845,5461,21825,17424,17664,16705,16644,16389,21824,16384,16640,17429,17669,16721,16660,16405,21845,21845,21845,21845,21845,21845,21845,21845,21845,21845,21845,21845,21845,21845,21845,21845,21845,20480,21825,17424,17664,16705,16644,16389,21824,16384,16640,17429,17669,16721,16660,16405,21845],"retardos":[[9.399999999999998e-8,9.699999999999998e-8],[9.399999999999998e-8,9.699999999999998e-8],[9.399999999999998e-8,9.699999999999998e-8],[9.399999999999998e-8,9.699999999999998e-8],[9.399999999999998e-8,9.699999999999998e-8],[9.399999999999998e-8,9.699999999999998e-8],[9.399999999999998e-8,9.699999999999998e-8],[9.399999999999998e-8,9.699999999999998e-8]],"abierta":[true,true,true,true,true,true,true,true]}
APU0_0 d0 uno_d
.options reltol=1e-4 abstol=1e-12 vntol=1e-7 xtrtol=7
.control
set wr_singlescale
set wr_vecnames
option numdgt=7
tran 1n 16000n 0 0.1n uic
wrdata salida.txt v(n1)
eprint d1 d2 d3 d4 d5 d6 d7 > eventos.txt
.endc
.end
