* Doble multiplexor 74LS153 a 5 V con seleccion comun, un estrobo por mitad y los ocho datos en pulsos
.model adc_0 adc_bridge(in_low=0.8 in_high=2 rise_delay=1e-12 fall_delay=1e-12)
.model uno_d d_pullup(load=1e-12)
V1 n1 0 PULSE(0 5 1e-7 1e-12 1e-12 3.99999e-7 8e-7)
V2 n2 0 PULSE(0 5 1.53e-7 1e-12 1e-12 8.99999e-7 0.0000017999999999985602)
V3 n3 0 PULSE(0 5 7e-7 1e-12 1e-12 0.0000013999990000000001 0.00000279999999999888)
V4 n4 0 PULSE(0 5 9.51e-7 1e-12 1e-12 0.000001799999 0.0000035999999999971203)
V5 n5 0 PULSE(0 5 0.000008 1e-12 1e-12 0.000001499999 0.000011000000000011)
V6 n6 0 PULSE(0 5 2.72e-7 1e-12 1e-12 9.33999e-7 0.0000018679999999985502)
V7 n7 0 PULSE(0 5 6e-7 1e-12 1e-12 0.000001099999 0.0000022000000000022)
V8 n8 0 PULSE(0 5 4e-7 1e-12 1e-12 0.000001299999 0.0000026000000000026)
V9 n9 0 PULSE(0 5 8.49e-7 1e-12 1e-12 0.000001699999 0.0000033999999999979604)
V10 n10 0 PULSE(0 5 0.000005 1e-12 1e-12 0.000001499999 0.000008)
V11 n11 0 PULSE(0 5 4.4e-7 1e-12 1e-12 9.299990000000001e-7 0.000001860000000000521)
V12 n12 0 PULSE(0 5 9e-7 1e-12 1e-12 0.000001199999 0.00000239999999999808)
AIN0 [n2] [d2] adc_0
AIN1 [n1] [d3] adc_0
AIN2 [n5] [d4] adc_0
AIN3 [n6] [d5] adc_0
AIN4 [n7] [d6] adc_0
AIN5 [n8] [d7] adc_0
AIN6 [n9] [d8] adc_0
AIN7 [n10] [d9] adc_0
AIN8 [n11] [d10] adc_0
AIN9 [n12] [d11] adc_0
AIN10 [n3] [d12] adc_0
AIN11 [n4] [d13] adc_0
*@generar lut u0 {"comunes":["d2","d3"],"rebanadas":[{"entradas":["d4","d5","d6","d7","d8"],"salidas":["d0"]},{"entradas":["d9","d10","d11","d12","d13"],"salidas":["d1"]}],"tabla":[0,0,0,0,0,0,0,0,1,1,1,1,1,1,1,1,0,0,0,0,0,0,0,0,0,0,0,0,0,0,0,0,0,0,0,0,1,1,1,1,0,0,0,0,1,1,1,1,0,0,0,0,0,0,0,0,0,0,0,0,0,0,0,0,0,0,1,1,0,0,1,1,0,0,1,1,0,0,1,1,0,0,0,0,0,0,0,0,0,0,0,0,0,0,0,0,0,1,0,1,0,1,0,1,0,1,0,1,0,1,0,1,0,0,0,0,0,0,0,0,0,0,0,0,0,0,0,0],"retardos":[[1.3e-8,2.1999999999999995e-8]]}
.options reltol=1e-4 abstol=1e-12 vntol=1e-7 xtrtol=7
.control
set wr_singlescale
set wr_vecnames
option numdgt=7
tran 1n 12000n 0 0.1n uic
wrdata salida.txt v(n1)
eprint d0 d1 > eventos.txt
.endc
.end
