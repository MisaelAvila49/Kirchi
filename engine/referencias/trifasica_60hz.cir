* Fuente trifasica de 180 V de pico a 60 Hz (fases a 0, -120 y 120 grados) con 1 k por fase
VA a 0 SIN(0 180 60 0 0 0)
VB b 0 SIN(0 180 60 0 0 -120)
VC c 0 SIN(0 180 60 0 0 120)
RA a 0 1k
RB b 0 1k
RC c 0 1k
.options reltol=1e-4 abstol=1e-12 vntol=1e-7
.control
set wr_singlescale
set wr_vecnames
option numdgt=7
tran 50u 34m 0 50u uic
wrdata salida.txt v(a) v(b) v(c)
.endc
.end
