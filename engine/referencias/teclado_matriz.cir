* Teclado de 2 x 2 (r_on de 100 ohm, r_off de 100 Mohm): la fila 1 a 5 V, la fila 2 a 2 V y cada columna con 1 kohm a tierra; ngspice hace cada tecla con una B de resistencia variable
V1 f1 0 DC 5
V2 f2 0 DC 2
R1 c1 0 1k
R2 c2 0 1k
VK0 k0 0 PWL(0 0 0.00003 0 0.000030000001 1 0.00009 1 0.000090000001 0)
B0 f1 c1 I=V(f1,c1)/(100meg+(100-100meg)*V(k0))
VK1 k1 0 PWL(0 0 0.00006 0 0.000060000001000000004 1 0.00015 1 0.00015000000099999998 0)
B1 f1 c2 I=V(f1,c2)/(100meg+(100-100meg)*V(k1))
VK2 k2 0 PWL(0 0)
B2 f2 c1 I=V(f2,c1)/(100meg+(100-100meg)*V(k2))
VK3 k3 0 PWL(0 0 0.00012 0 0.000120000001 1)
B3 f2 c2 I=V(f2,c2)/(100meg+(100-100meg)*V(k3))
.options reltol=1e-4 abstol=1e-12 vntol=1e-7
.control
set wr_singlescale
set wr_vecnames
option numdgt=7
tran 10n 200u 0 10n
wrdata salida.txt v(c1) v(c2)
.endc
.end
