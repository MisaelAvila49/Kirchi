* Fuente de corriente controlada por voltaje de 3 mS que baja el nodo de una carga de 1 kohm
V1 1 0 DC 2
V2 3 0 DC 5
RL 3 2 1k
G1 2 0 1 0 3m
.options reltol=1e-4 abstol=1e-12 vntol=1e-7
.control
set wr_singlescale
set wr_vecnames
option numdgt=7
op
wrdata salida.txt v(2) i(v2)
.endc
.end
