* LM386 con 6 V, entradas en tierra y sin carga: salida en la mitad de la alimentacion y corriente en reposo
.include modelos.lib
V1 vs 0 DC 6
VNEG 0 vneg DC 0.5
RIN1 inm 0 50000
RIN2 inp 0 50000
XB1 inm bn bn vs vneg AMPOP a0=200000 gbw=10000000 sr=1000000 rin=1000000000000 rout=10 ilim=0.01 dhi=1 dlo=0.01 rq=1000000000000
XB2 inp bp bp vs vneg AMPOP a0=200000 gbw=10000000 sr=1000000 rin=1000000000000 rout=10 ilim=0.01 dhi=1 dlo=0.01 rq=1000000000000
R1 bn g8 150
R2 g8 g1 1350
R3 bp pa 150
R4 pa np 1350
R5 out g1 30000
R6 np vb 30000
R7 vs byp 15000
R8 byp 0 15000
XB3 byp vb vb vs 0 AMPOP a0=200000 gbw=10000000 sr=1000000 rin=1000000000000 rout=10 ilim=0.01 dhi=1 dlo=0.01 rq=1000000000000
XU3 np g1 out vs 0 AMPOP a0=200000 gbw=6300000 sr=300000 rin=1000000000 rout=1 ilim=0.6 dhi=0.4 dlo=0.4 rq=1579
RX out 0 1G
.options reltol=1e-4 abstol=1e-12 vntol=1e-7
.control
set wr_singlescale
set wr_vecnames
option numdgt=7
op
wrdata salida.txt v(out) v(byp) i(v1)
.endc
.end
