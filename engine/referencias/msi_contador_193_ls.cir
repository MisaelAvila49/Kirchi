* Contador binario 74LS193 a 5 V con dos relojes, borrado y carga asincronos al azar
.model adc_0 adc_bridge(in_low=0.8 in_high=2 rise_delay=1e-12 fall_delay=1e-12)
V1 n1 0 PWL(0 0 6e-8 0 6.00001e-8 5 3e-7 5 3.000001e-7 0 8e-7 0 8.000001e-7 5 0.0000023 5 0.0000023000001000000004 0 0.0000028 0 0.0000028000001000000002 5 0.0000043 5 0.0000043000001 0 0.0000048 0 0.0000048000001000000006 5 0.0000063 5 0.000006300000100000001 0 0.0000068 0 0.0000068000001 5 0.0000083 5 0.0000083000001 0 0.0000088 0 0.000008800000099999999 5 0.0000103 5 0.0000103000001 0 0.0000108 0 0.0000108000001 5 0.0000123 5 0.000012300000099999999 0 0.0000128 0 0.0000128000001 5 0.0000143 5 0.000014300000099999999 0 0.0000148 0 0.000014800000099999999 5 0.0000163 5 0.000016300000099999998 0 0.0000168 0 0.0000168000001 5 0.0000183 5 0.000018300000100000003 0 0.0000188 0 0.0000188000001 5 0.0000203 5 0.0000203000001 0 0.0000208 0 0.000020800000100000002 5 0.0000223 5 0.0000223000001 0 0.0000228 0 0.0000228000001 5 0.0000243 5 0.000024300000100000003 0 0.0000248 0 0.0000248000001 5 0.0000263 5 0.0000263000001 0 0.0000268 0 0.000026800000100000003 5 0.0000283 5 0.000028300000100000002 0 0.0000288 0 0.0000288000001 5 0.0000303 5 0.0000303000001 0 0.0000308 0 0.0000308000001 5 0.0000323 5 0.000032300000100000004 0 0.0000328 0 0.000032800000099999996 5 0.0000343 5 0.0000343000001 0 0.0000348 0 0.0000348000001 5 0.0000363 5 0.0000363000001 0 0.0000368 0 0.0000368000001 5 0.0000383 5 0.0000383000001 0 0.0000388 0 0.0000388000001 5 0.0000403 5 0.000040300000099999995 0 0.0000408 0 0.0000408000001 5 0.0000423 5 0.000042300000099999996 0 0.0000428 0 0.000042800000099999995 5 0.0000443 5 0.0000443000001 0 0.0000448 0 0.000044800000099999996 5 0.0000463 5 0.0000463000001 0 0.0000468 0 0.0000468000001 5 0.0000483 5 0.0000483000001 0 0.0000488 0 0.0000488000001 5 0.0000503 5 0.000050300000099999994 0 0.0000508 0 0.0000508000001 5 0.0000523 5 0.000052300000099999996 0 0.0000528 0 0.000052800000099999994 5 0.0000543 5 0.0000543000001 0 0.0000548 0 0.000054800000099999995 5 0.0000563 5 0.0000563000001 0 0.0000568 0 0.000056800000099999997 5 0.0000583 5 0.0000583000001 0 0.0000588 0 0.0000588000001 5 0.0000603 5 0.0000603000001 0 0.0000608 0 0.0000608000001 5 0.0000623 5 0.0000623000001 0 0.0000628 0 0.0000628000001 5 0.0000643 5 0.0000643000001 0 0.0000648 0 0.0000648000001 5 0.0000663 5 0.0000663000001 0 0.0000668 0 0.0000668000001 5 0.0000683 5 0.0000683000001 0 0.0000688 0 0.00006880000010000001 5 0.0000703 5 0.0000703000001 0 0.0000708 0 0.0000708000001 5 0.0000723 5 0.0000723000001 0 0.0000728 0 0.0000728000001 5 0.0000743 5 0.00007430000010000001 0 0.0000748 0 0.00007480000010000001 5 0.0000763 5 0.0000763000001 0 0.0000768 0 0.0000768000001 5 0.0000783 5 0.00007830000010000001 0 0.0000788 0 0.00007880000010000001 5)
V2 n2 0 PWL(0 0 2e-8 0 2.00001e-8 5 0.0000013 5 0.0000013000001 0 0.0000018 0 0.0000018000001 5 0.0000033 5 0.0000033000001 0 0.0000038 0 0.0000038000001000000004 5 0.0000053 5 0.0000053000001 0 0.0000058 0 0.0000058000001 5 0.0000073 5 0.0000073000001 0 0.0000078 0 0.0000078000001 5 0.0000093 5 0.000009300000099999999 0 0.0000098 0 0.0000098000001 5 0.0000113 5 0.000011300000099999998 0 0.0000118 0 0.000011800000099999999 5 0.0000133 5 0.0000133000001 0 0.0000138 0 0.0000138000001 5 0.0000153 5 0.0000153000001 0 0.0000158 0 0.0000158000001 5 0.0000173 5 0.000017300000100000002 0 0.0000178 0 0.0000178000001 5 0.0000193 5 0.0000193000001 0 0.0000198 0 0.000019800000100000002 5 0.0000213 5 0.0000213000001 0 0.0000218 0 0.0000218000001 5 0.0000233 5 0.000023300000100000002 0 0.0000238 0 0.0000238000001 5 0.0000253 5 0.0000253000001 0 0.0000258 0 0.000025800000100000002 5 0.0000273 5 0.0000273000001 0 0.0000278 0 0.0000278000001 5 0.0000293 5 0.000029300000100000002 0 0.0000298 0 0.0000298000001 5 0.0000313 5 0.0000313000001 0 0.0000318 0 0.0000318000001 5 0.0000333 5 0.000033300000099999995 0 0.0000338 0 0.0000338000001 5 0.0000353 5 0.000035300000099999996 0 0.0000358 0 0.000035800000099999994 5 0.0000373 5 0.0000373000001 0 0.0000378 0 0.000037800000099999995 5 0.0000393 5 0.0000393000001 0 0.0000398 0 0.0000398000001 5 0.0000413 5 0.0000413000001 0 0.0000418 0 0.0000418000001 5 0.0000433 5 0.0000433000001 0 0.0000438 0 0.0000438000001 5 0.0000453 5 0.000045300000099999995 0 0.0000458 0 0.0000458000001 5 0.0000473 5 0.000047300000099999996 0 0.0000478 0 0.000047800000099999995 5 0.0000493 5 0.0000493000001 0 0.0000498 0 0.000049800000099999996 5 0.0000513 5 0.0000513000001 0 0.0000518 0 0.0000518000001 5 0.0000533 5 0.0000533000001 0 0.0000538 0 0.0000538000001 5 0.0000553 5 0.0000553000001 0 0.0000558 0 0.0000558000001 5 0.0000573 5 0.000057300000099999995 0 0.0000578 0 0.0000578000001 5 0.0000593 5 0.000059300000099999996 0 0.0000598 0 0.000059800000099999995 5 0.0000613 5 0.00006130000009999999 0 0.0000618 0 0.0000618000001 5 0.0000633 5 0.0000633000001 0 0.0000638 0 0.0000638000001 5 0.0000653 5 0.00006530000009999999 0 0.0000658 0 0.0000658000001 5 0.0000673 5 0.0000673000001 0 0.0000678 0 0.0000678000001 5 0.0000693 5 0.00006930000010000001 0 0.0000698 0 0.00006980000010000001 5 0.0000713 5 0.0000713000001 0 0.0000718 0 0.0000718000001 5 0.0000733 5 0.00007330000010000001 0 0.0000738 0 0.00007380000010000001 5 0.0000753 5 0.0000753000001 0 0.0000758 0 0.0000758000001 5 0.0000773 5 0.0000773000001 0 0.0000778 0 0.0000778000001 5 0.0000793 5 0.00007930000010000001 0 0.0000798 0 0.0000798000001 5)
V3 n3 0 PWL(0 0 0.00000845 0 0.000008450000099999999 5 0.0000086 5 0.000008600000099999999 0 0.00004145 0 0.000041450000099999996 5 0.0000416 5 0.0000416000001 0 0.00006245 0 0.00006245000009999999 5 0.0000626 5 0.0000626000001 0)
V4 n4 0 PWL(0 5 0.00000715 5 0.0000071500001 0 0.00000728 0 0.0000072800001000000005 5 0.00002115 5 0.0000211500001 0 0.00002128 0 0.0000212800001 5 0.00005815 5 0.000058150000099999995 0 0.00005828 0 0.000058280000099999996 5 0.00006115 5 0.0000611500001 0 0.00006128 0 0.0000612800001 5 0.00006715 5 0.00006715000010000001 0 0.00006728 0 0.00006728000010000001 5 0.00007215 5 0.00007215000010000001 0 0.00007228 0 0.00007228000010000001 5 0.00007815 5 0.00007815000010000001 0 0.00007828 0 0.00007828000010000001 5 0.00007915 5 0.0000791500001 0 0.00007928 0 0.0000792800001 5)
V5 n5 0 PWL(0 0 0.0000091 0 0.0000091000001 5 0.0000101 5 0.0000101000001 0 0.0000121 0 0.0000121000001 5 0.0000241 5 0.0000241000001 0 0.0000311 0 0.0000311000001 5 0.0000341 5 0.0000341000001 0 0.0000401 0 0.0000401000001 5 0.0000421 5 0.0000421000001 0 0.0000451 0 0.0000451000001 5 0.0000521 5 0.0000521000001 0 0.0000551 0 0.000055100000099999996 5 0.0000591 5 0.0000591000001 0 0.0000601 0 0.000060100000099999995 5 0.0000661 5 0.0000661000001 0 0.0000731 0 0.0000731000001 5 0.0000751 5 0.0000751000001 0)
V6 n6 0 PWL(0 0 1e-7 0 1.000001e-7 5 0.0000041 5 0.0000041000001000000005 0 0.0000141 0 0.000014100000099999999 5 0.0000151 5 0.0000151000001 0 0.0000161 0 0.0000161000001 5 0.0000181 5 0.0000181000001 0 0.0000191 0 0.000019100000100000002 5 0.0000261 5 0.000026100000100000002 0 0.0000331 0 0.000033100000099999996 5 0.0000351 5 0.0000351000001 0 0.0000361 0 0.000036100000099999995 5 0.0000381 5 0.000038100000099999996 0 0.0000391 0 0.0000391000001 5 0.0000401 5 0.0000401000001 0 0.0000441 0 0.0000441000001 5 0.0000491 5 0.0000491000001 0 0.0000521 0 0.0000521000001 5 0.0000541 5 0.0000541000001 0 0.0000551 0 0.000055100000099999996 5 0.0000581 5 0.000058100000099999994 0 0.0000641 0 0.00006410000009999999 5 0.0000651 5 0.0000651000001 0 0.0000661 0 0.0000661000001 5 0.0000671 5 0.00006710000010000001 0 0.0000681 0 0.00006810000010000001 5 0.0000691 5 0.0000691000001 0 0.0000701 0 0.0000701000001 5 0.0000741 5 0.0000741000001 0 0.0000751 0 0.0000751000001 5 0.0000771 5 0.00007710000010000001 0 0.0000781 0 0.0000781000001 5)
V7 n7 0 PWL(0 0 0.0000021 0 0.0000021000001 5 0.0000091 5 0.0000091000001 0 0.0000101 0 0.0000101000001 5 0.0000121 5 0.0000121000001 0 0.0000141 0 0.000014100000099999999 5 0.0000161 5 0.0000161000001 0 0.0000181 0 0.0000181000001 5 0.0000221 5 0.0000221000001 0 0.0000271 0 0.0000271000001 5 0.0000341 5 0.0000341000001 0 0.0000361 0 0.000036100000099999995 5 0.0000371 5 0.0000371000001 0 0.0000381 0 0.000038100000099999996 5 0.0000401 5 0.0000401000001 0 0.0000421 0 0.0000421000001 5 0.0000441 5 0.0000441000001 0 0.0000631 0 0.0000631000001 5 0.0000661 5 0.0000661000001 0 0.0000671 0 0.00006710000010000001 5 0.0000691 5 0.0000691000001 0 0.0000701 0 0.0000701000001 5 0.0000711 5 0.0000711000001 0 0.0000721 0 0.00007210000010000001 5 0.0000731 5 0.0000731000001 0 0.0000771 0 0.00007710000010000001 5)
V8 n8 0 PWL(0 0 0.0000071 0 0.0000071000001000000006 5 0.0000101 5 0.0000101000001 0 0.0000111 0 0.000011100000099999999 5 0.0000141 5 0.000014100000099999999 0 0.0000161 0 0.0000161000001 5 0.0000171 5 0.0000171000001 0 0.0000181 0 0.0000181000001 5 0.0000201 5 0.000020100000100000002 0 0.0000231 0 0.0000231000001 5 0.0000271 5 0.0000271000001 0 0.0000281 0 0.0000281000001 5 0.0000411 5 0.000041100000099999994 0 0.0000421 0 0.0000421000001 5 0.0000481 5 0.000048100000099999995 0 0.0000501 0 0.000050100000099999996 5 0.0000571 5 0.0000571000001 0 0.0000611 0 0.0000611000001 5 0.0000631 5 0.0000631000001 0 0.0000641 0 0.00006410000009999999 5 0.0000671 5 0.00006710000010000001 0 0.0000711 0 0.0000711000001 5 0.0000741 5 0.0000741000001 0 0.0000761 0 0.0000761000001 5 0.0000791 5 0.0000791000001 0)
AIN0 [n1] [d6] adc_0
AIN1 [n2] [d7] adc_0
AIN2 [n3] [d8] adc_0
AIN3 [n4] [d9] adc_0
AIN4 [n5] [d10] adc_0
AIN5 [n6] [d11] adc_0
AIN6 [n7] [d12] adc_0
AIN7 [n8] [d13] adc_0
*@generar msi u0 {"entradas":["d6","d7","d8","d9","d10","d11","d12","d13"],"salidas":["d0","d1","d2","d3","d4","d5"],"nucleo":{"tipo":"contador","bits":4,"modulo":16,"reloj":{"senales":[{"entrada":0}],"flanco":"subida"},"abajo":{"senales":[{"entrada":1}],"flanco":"subida"},"borra":{"senal":{"entrada":2},"sincrona":false},"carga":{"senal":{"entrada":3,"bajo":true},"sincrona":false,"datos":[4,5,6,7]}},"de":[{"tipo":"directa","fuente":{"bit":0}},{"tipo":"directa","fuente":{"bit":1}},{"tipo":"directa","fuente":{"bit":2}},{"tipo":"directa","fuente":{"bit":3}},{"tipo":"tabla","columna":0},{"tipo":"tabla","columna":1}],"fuentes":[{"entrada":0},{"entrada":1},{"bit":3},{"bit":2},{"bit":1},{"bit":0}],"tabla":[1,5,5,5,5,5,5,5,5,5,5,5,5,5,5,4,5,5,5,5,5,5,5,5,5,5,5,5,5,5,5,4,1,5,5,5,5,5,5,5,5,5,5,5,5,5,5,5,5,5,5,5,5,5,5,5,5,5,5,5,5,5,5,5],"retardos":[[2.1000000000000003e-8,2.6999999999999997e-8],[2.1000000000000003e-8,2.6999999999999997e-8],[2.1000000000000003e-8,2.6999999999999997e-8],[2.1000000000000003e-8,2.6999999999999997e-8],[1.1e-8,1.5e-8],[1e-8,1.1999999999999998e-8]]}
.options reltol=1e-4 abstol=1e-12 vntol=1e-7 xtrtol=7
.control
set wr_singlescale
set wr_vecnames
option numdgt=7
tran 1n 80000n 0 0.1n uic
wrdata salida.txt v(n1)
eprint d0 d1 d2 d3 d4 d5 > eventos.txt
.endc
.end
