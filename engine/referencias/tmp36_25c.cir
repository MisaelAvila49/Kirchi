* TMP36 con 5 V y 10 kOhm de carga a 25 C: fuente de 0.5 V mas 10 mV por grado y seguidor del motor
VT tsens 0 DC 0.75
.include modelos.lib
V1 vcc 0 DC 5
RL out 0 10k
XU1 tsens out out vcc 0 AMPOP a0=100000 gbw=1000000 sr=1000000 rin=1000000000000 rout=60 ilim=0.00025 dhi=1.5 dlo=0.01 rq=101000
.options reltol=1e-4 abstol=1e-12 vntol=1e-7
.control
set wr_singlescale
set wr_vecnames
option numdgt=7
op
wrdata salida.txt v(out) i(v1)
.endc
.end
