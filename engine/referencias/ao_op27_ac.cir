* Inversor de ganancia 10 con OP27 a GBW/10, para comparar su respuesta en frecuencia
.include modelos.lib
V1 1 0 DC 15
V2 2 0 DC -15
VIN 3 0 SIN(0 0.05 800000)
RI 3 4 1k
RF 4 5 10k
RL 5 0 10k
XU1 0 4 5 1 2 AMPOP a0=1800000 gbw=8000000 sr=2800000 rin=6000000 rout=70 ilim=0.025 dhi=0.72 dlo=0.72 rq=10000
.options reltol=1e-4 abstol=1e-12 vntol=1e-7
.control
set wr_singlescale
set wr_vecnames
option numdgt=7
tran 3.125e-09 3.75e-06 0 1.5625e-09 uic
wrdata salida.txt v(5)
.endc
.end
