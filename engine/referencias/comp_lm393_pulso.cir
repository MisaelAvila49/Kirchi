* Comparador LM393 con escalon grande y 5.1 k a 5 V
.include modelos.lib
V1 1 0 DC 5
V2 2 0 DC 0
VIN 3 0 PULSE(0 5 0 1p 1p 9.999999u 20u)
V4 4 0 DC 2.5
V8 8 0 DC 5
RL 8 5 5.1k
* sin CL
XU1 3 4 6 1 2 AMPOP a0=200000 gbw=1.15e+08 sr=2e+07 rin=1e+08 rout=100 ilim=0.03 dhi=0.05 dlo=0.001 rq=22200
RB 6 7 2200
Q1 5 7 2 QCMP393
.options reltol=1e-4 abstol=1e-12 vntol=1e-7
.control
set wr_singlescale
set wr_vecnames
option numdgt=7
tran 20n 40u 0 10n uic
wrdata salida.txt v(5)
.endc
.end
