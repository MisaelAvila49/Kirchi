* Disparador Schmitt 74HC a 5 V (VT+ 2.7667 V y VT- 1.7333 V) con un seno de 1 kHz y su inversor de 5 ns
.include digital.lib
VIN in 0 SIN(2.25 2.5 1k)
VCC vcc 0 5
S1 vcc hn in 0 sw_hc14
RH hn 0 1k
AB [hn] [dh] adc_hc5
AU1 dh dy inv_hc5
AS [dy] [o1] dac_hc5
RO o1 y 55
R1 y 0 10k
.options reltol=1e-4 abstol=1e-12 vntol=1e-7 xtrtol=7
.control
set wr_singlescale
set wr_vecnames
option numdgt=7
tran 1u 2m 0 1u uic
wrdata salida.txt v(y) v(in)
eprint dh dy > eventos.txt
.endc
.end
