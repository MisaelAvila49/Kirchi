* Diodo 1N4148 a unos 10 mA (corriente de prueba de VF de la hoja de datos)
.include modelos.lib
V1 1 0 DC 5
R1 1 2 430
D1 2 0 D1N4148
.options reltol=1e-4 abstol=1e-12 vntol=1e-7
.control
set wr_singlescale
set wr_vecnames
option numdgt=7
op
wrdata salida.txt v(2) i(v1)
.endc
.end
