* Fuente de voltaje controlada por voltaje de ganancia 4 con un divisor de carga
V1 1 0 DC 0.5
R1 1 0 1k
E1 2 0 1 0 4
R2 2 3 1k
R3 3 0 2k
.options reltol=1e-4 abstol=1e-12 vntol=1e-7
.control
set wr_singlescale
set wr_vecnames
option numdgt=7
op
wrdata salida.txt v(2) v(3) i(v1)
.endc
.end
