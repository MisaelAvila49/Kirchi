* Fuente controlada de ganancia 3 que maneja un filtro RC con una senoidal
VIN 1 0 SIN(0 1 1k)
E1 2 0 1 0 3
R1 2 3 1k
C1 3 0 100n
.options reltol=1e-4 abstol=1e-12 vntol=1e-7
.control
set wr_singlescale
set wr_vecnames
option numdgt=7
tran 10u 5m 0 2u uic
wrdata salida.txt v(2) v(3) i(vin)
.endc
.end
