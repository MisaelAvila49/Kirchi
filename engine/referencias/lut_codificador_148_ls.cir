* Codificador de prioridad 74LS148 a 5 V con las ocho entradas activas en bajo en pulsos y EI en pulso
.model adc_0 adc_bridge(in_low=0.8 in_high=2 rise_delay=1e-12 fall_delay=1e-12)
.model uno_d d_pullup(load=1e-12)
V1 n1 0 PULSE(0 5 0.000009 1e-12 1e-12 0.000001499999 0.000012000000000048)
V2 n2 0 PULSE(0 5 1e-7 1e-12 1e-12 3.09999e-7 6.200000000001736e-7)
V3 n3 0 PULSE(0 5 2.08e-7 1e-12 1e-12 6.169990000000001e-7 0.0000012339999999998149)
V4 n4 0 PULSE(0 5 5.58e-7 1e-12 1e-12 6.24999e-7 0.00000125)
V5 n5 0 PULSE(0 5 2.59e-7 1e-12 1e-12 6.199990000000001e-7 0.0000012400000000003473)
V6 n6 0 PULSE(0 5 4.77e-7 1e-12 1e-12 0.000001238999 0.0000024779999999992515)
V7 n7 0 PULSE(0 5 0.00000108 1e-12 1e-12 0.000001246999 0.0000024939999999993962)
V8 n8 0 PULSE(0 5 9.35e-7 1e-12 1e-12 0.0000012419990000000001 0.0000024840000000000697)
V9 n9 0 PULSE(0 5 0.000001131 1e-12 1e-12 0.000001249999 0.0000025)
AIN0 [n1] [d5] adc_0
AIN1 [n2] [d6] adc_0
AIN2 [n3] [d7] adc_0
AIN3 [n4] [d8] adc_0
AIN4 [n5] [d9] adc_0
AIN5 [n6] [d10] adc_0
AIN6 [n7] [d11] adc_0
AIN7 [n8] [d12] adc_0
AIN8 [n9] [d13] adc_0
*@generar lut u0 {"comunes":["d5","d6","d7","d8","d9","d10","d11","d12","d13"],"rebanadas":[{"entradas":[],"salidas":["d0","d1","d2","d3","d4"]}],"tabla":[256,272,256,260,256,272,256,276,256,272,256,260,256,272,256,257,256,272,256,260,256,272,256,276,256,272,256,260,256,272,256,273,256,272,256,260,256,272,256,276,256,272,256,260,256,272,256,257,256,272,256,260,256,272,256,276,256,272,256,260,256,272,256,261,256,272,256,260,256,272,256,276,256,272,256,260,256,272,256,257,256,272,256,260,256,272,256,276,256,272,256,260,256,272,256,273,256,272,256,260,256,272,256,276,256,272,256,260,256,272,256,257,256,272,256,260,256,272,256,276,256,272,256,260,256,272,256,277,256,272,256,260,256,272,256,276,256,272,256,260,256,272,256,257,256,272,256,260,256,272,256,276,256,272,256,260,256,272,256,273,256,272,256,260,256,272,256,276,256,272,256,260,256,272,256,257,256,272,256,260,256,272,256,276,256,272,256,260,256,272,256,261,256,272,256,260,256,272,256,276,256,272,256,260,256,272,256,257,256,272,256,260,256,272,256,276,256,272,256,260,256,272,256,273,256,272,256,260,256,272,256,276,256,272,256,260,256,272,256,257,256,272,256,260,256,272,256,276,256,272,256,260,256,272,256,85,341,341,341,341,341,341,341,341,341,341,341,341,341,341,341,341,341,341,341,341,341,341,341,341,341,341,341,341,341,341,341,341,341,341,341,341,341,341,341,341,341,341,341,341,341,341,341,341,341,341,341,341,341,341,341,341,341,341,341,341,341,341,341,341,341,341,341,341,341,341,341,341,341,341,341,341,341,341,341,341,341,341,341,341,341,341,341,341,341,341,341,341,341,341,341,341,341,341,341,341,341,341,341,341,341,341,341,341,341,341,341,341,341,341,341,341,341,341,341,341,341,341,341,341,341,341,341,341,341,341,341,341,341,341,341,341,341,341,341,341,341,341,341,341,341,341,341,341,341,341,341,341,341,341,341,341,341,341,341,341,341,341,341,341,341,341,341,341,341,341,341,341,341,341,341,341,341,341,341,341,341,341,341,341,341,341,341,341,341,341,341,341,341,341,341,341,341,341,341,341,341,341,341,341,341,341,341,341,341,341,341,341,341,341,341,341,341,341,341,341,341,341,341,341,341,341,341,341,341,341,341,341,341,341,341,341,341,341,341,341,341,341,341,341,341,341,341,341,341,341,341,341,341,341,341,341],"retardos":[[1.4e-8,1.3e-8],[1.4e-8,1.3e-8],[1.4e-8,1.3e-8],[2.9e-8,5.999999999999999e-9],[1.0000000000000007e-9,2.1999999999999995e-8]]}
.options reltol=1e-4 abstol=1e-12 vntol=1e-7 xtrtol=7
.control
set wr_singlescale
set wr_vecnames
option numdgt=7
tran 1n 12000n 0 0.1n uic
wrdata salida.txt v(n1)
eprint d0 d1 d2 d3 d4 > eventos.txt
.endc
.end
