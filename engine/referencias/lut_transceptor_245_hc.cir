* Transceptor 74HC245 a 4.5 V entre dos bufers 74HC244 que manejan cada lado por turnos: el sentido DIR, la habilitacion OE y los datos en pulsos
.model adc_0 adc_bridge(in_low=1.3499999999999999 in_high=3.15 rise_delay=1e-12 fall_delay=1e-12)
.model uno_d d_pullup(load=1e-12)
V1 n1 0 PULSE(0 4.5 0.000003 1e-12 1e-12 0.0000059999899999999995 0.000012000000000048)
V2 n2 0 PULSE(0 4.5 0.000003 1e-12 1e-12 0.0000059999899999999995 0.000012000000000048)
V3 n3 0 PULSE(0 4.5 4.54e-7 1e-12 1e-12 0.000001331999 0.000002664000000002664)
V4 n4 0 PULSE(0 4.5 0.00000145 1e-12 1e-12 0.000001549999 0.0000031000000000027897)
V5 n6 0 PULSE(0 4.5 0 1e-12 1e-12 0.00000299999 0.000009000000000008999)
V6 n5 0 PULSE(0 4.5 0.0000028 1e-12 1e-12 5.9999e-7 0.000005999999999987999)
V7 n7 0 PULSE(0 4.5 1e-7 1e-12 1e-12 3.99999e-7 8e-7)
V8 n8 0 PULSE(0 4.5 1.5e-7 1e-12 1e-12 6.99999e-7 0.00000139999999999944)
V9 n9 0 PULSE(0 4.5 6.5e-7 1e-12 1e-12 0.000001099999 0.0000022000000000022)
V10 n10 0 PULSE(0 4.5 7e-7 1e-12 1e-12 0.000001499999 0.000003000000000003)
V11 n11 0 PULSE(0 4.5 3.65e-7 1e-12 1e-12 7.87999e-7 0.0000015760000000011473)
V12 n12 0 PULSE(0 4.5 8.11e-7 1e-12 1e-12 0.000001191999 0.000002384000000001831)
AIN0 [n5] [d16] adc_0
AIN1 [n1] [d17] adc_0
AIN2 [n6] [d18] adc_0
AIN3 [n7] [d19] adc_0
AIN4 [n8] [d20] adc_0
AIN5 [n9] [d21] adc_0
AIN6 [n10] [d22] adc_0
AIN7 [n6] [d23] adc_0
AIN8 [n7] [d24] adc_0
AIN9 [n8] [d25] adc_0
AIN10 [n9] [d26] adc_0
AIN11 [n10] [d27] adc_0
AIN12 [n2] [d28] adc_0
AIN13 [n11] [d29] adc_0
AIN14 [n12] [d30] adc_0
AIN15 [n3] [d31] adc_0
AIN16 [n4] [d32] adc_0
AIN17 [n2] [d33] adc_0
AIN18 [n11] [d34] adc_0
AIN19 [n12] [d35] adc_0
AIN20 [n3] [d36] adc_0
AIN21 [n4] [d37] adc_0
*@generar lut u0 {"comunes":["d16","d17"],"rebanadas":[{"entradas":["d0","d1"],"salidas":["d0","d1"]},{"entradas":["d2","d3"],"salidas":["d2","d3"]},{"entradas":["d4","d5"],"salidas":["d4","d5"]},{"entradas":["d6","d7"],"salidas":["d6","d7"]},{"entradas":["d8","d9"],"salidas":["d8","d9"]},{"entradas":["d10","d11"],"salidas":["d10","d11"]},{"entradas":["d12","d13"],"salidas":["d12","d13"]},{"entradas":["d14","d15"],"salidas":["d14","d15"]}],"tabla":[8,9,8,9,2,2,6,6,10,10,10,10,10,10,10,10],"retardos":[[1.1499999999999999e-8,1.1499999999999999e-8],[1.1499999999999999e-8,1.1499999999999999e-8]]}
*@generar lut u1 {"comunes":[],"rebanadas":[{"entradas":["d18","d19"],"salidas":["d0"]},{"entradas":["d18","d20"],"salidas":["d2"]},{"entradas":["d18","d21"],"salidas":["d4"]},{"entradas":["d18","d22"],"salidas":["d6"]},{"entradas":["d23","d24"],"salidas":["d8"]},{"entradas":["d23","d25"],"salidas":["d10"]},{"entradas":["d23","d26"],"salidas":["d12"]},{"entradas":["d23","d27"],"salidas":["d14"]}],"tabla":[0,1,2,2],"retardos":[[9.5e-9,9.5e-9]]}
*@generar lut u2 {"comunes":[],"rebanadas":[{"entradas":["d28","d29"],"salidas":["d1"]},{"entradas":["d28","d30"],"salidas":["d3"]},{"entradas":["d28","d31"],"salidas":["d5"]},{"entradas":["d28","d32"],"salidas":["d7"]},{"entradas":["d33","d34"],"salidas":["d9"]},{"entradas":["d33","d35"],"salidas":["d11"]},{"entradas":["d33","d36"],"salidas":["d13"]},{"entradas":["d33","d37"],"salidas":["d15"]}],"tabla":[0,1,2,2],"retardos":[[9.5e-9,9.5e-9]]}
.options reltol=1e-4 abstol=1e-12 vntol=1e-7 xtrtol=7
.control
set wr_singlescale
set wr_vecnames
option numdgt=7
tran 1n 12000n 0 0.1n uic
wrdata salida.txt v(n1)
eprint d0 d1 d2 d3 d4 d5 d6 d7 d8 d9 d10 d11 d12 d13 d14 d15 > eventos.txt
.endc
.end
