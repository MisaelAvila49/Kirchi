* NPN 2N3055 con unos 1.5 A
.include modelos.lib
V1 1 0 DC 12
RB 1 2 270
RC 1 3 5
Q1 3 2 0 Q2N3055
.options reltol=1e-4 abstol=1e-12 vntol=1e-7
.control
set wr_singlescale
set wr_vecnames
option numdgt=7
op
wrdata salida.txt v(2) v(3) i(v1)
.endc
.end
