* Autopolarizacion de un JFET 2N3819 de canal N con resistencia en la fuente
.model J2N3819 NJF(VTO=-3.63636 BETA=0.000727891 LAMBDA=0.0025974 IS=1e-14 N=1 PB=1 CGS=1.5e-12 CGD=2.8e-12 RD=0 RS=0)
V1 1 0 DC 15
RG 2 0 1Meg
RS 3 0 470
RD 1 4 1k
J1 4 2 3 J2N3819
.options reltol=1e-4 abstol=1e-12 vntol=1e-7
.control
set wr_singlescale
set wr_vecnames
option numdgt=7
op
wrdata salida.txt v(3) v(4) i(v1)
.endc
.end
