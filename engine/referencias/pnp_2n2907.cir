* Polarizacion de un PNP 2N2907 con el emisor hacia la alimentacion
.include modelos.lib
V1 1 0 DC 12
R1 1 2 10k
R2 2 0 47k
RE 1 4 470
RC 3 0 2.2k
Q1 3 2 4 Q2N2907
.options reltol=1e-4 abstol=1e-12 vntol=1e-7
.control
set wr_singlescale
set wr_vecnames
option numdgt=7
save all @q1[ic] @q1[ib]
op
wrdata salida.txt v(2) v(3) v(4) i(v1) @q1[ic] @q1[ib]
.endc
.end
