* Amplificador inversor con una fuente controlada de ganancia 1e5 como amplificador operacional
V1 1 0 DC 1
R1 1 2 1k
R2 2 3 10k
E1 3 0 0 2 1e5
.options reltol=1e-4 abstol=1e-12 vntol=1e-7
.control
set wr_singlescale
set wr_vecnames
option numdgt=7
op
wrdata salida.txt v(2) v(3) i(v1)
.endc
.end
