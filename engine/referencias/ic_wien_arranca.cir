* Oscilador de puente de Wien (10 kohm y 16 nF, cerca de 1 kHz) que arranca solo de los 10 mV iniciales de un capacitor
.include modelos.lib
E1 o 0 p n 100k
R1 o a 10k
C1 a p 16n
R2 p 0 10k
C2 p 0 16n ic=10m
RF1 o m 15k
RF2 m n 10k
D1 m n DGEN
D2 n m DGEN
RG n 0 10k
.options reltol=1e-4 abstol=1e-12 vntol=1e-7
.control
set wr_singlescale
set wr_vecnames
option numdgt=7
tran 2u 20m 0 2u uic
wrdata salida.txt v(o) v(p)
.endc
.end
