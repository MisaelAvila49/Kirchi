* LM4040 de 2.5 V con una alimentacion de 0 a 12 V a 1 kHz y 1 k: arranque y apagado
.include modelos.lib
V1 vcc 0 PULSE(0 12 0 1p 1p 499.999999u 1m)
R1 vcc k 1k
XU1 tap vr g k ae AMPOP a0=20000 gbw=500000000 sr=1000000000 rin=1000000000000 rout=500 ilim=0.005 dhi=0.8 dlo=0.01 rq=1000000000000
VREF vr ae DC 1.225
Q1 k g ae QTL431
RS ae 0 0.3
D1 0 k DTL431
RK k tap 208148
RT tap ae 200000
.options reltol=1e-4 abstol=1e-12 vntol=1e-7 method=gear
.control
set wr_singlescale
set wr_vecnames
option numdgt=7
tran 1u 3m 0 1u uic
wrdata salida.txt v(k) i(v1)
.endc
.end
