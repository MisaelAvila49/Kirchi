* Generador senoidal de 1 kHz y 2 Vpp que pasa a 2 kHz en t = 1.25 ms con la fase continua (lo que hace el generador de Kirchi)
B1 1 0 V = sin(2*3.141592653589793*(time < 1.25m ? 1k*time : 1.25 + 2k*(time - 1.25m)))
RS 1 2 50
RL 2 0 1k
.options reltol=1e-4 abstol=1e-12 vntol=1e-7
.control
set wr_singlescale
set wr_vecnames
option numdgt=7
tran 1u 3m 0 1u uic
wrdata salida.txt v(1) v(2)
.endc
.end
