* MOSFET N IRF520 en saturacion
.include modelos.lib
V1 1 0 DC 12
R1 1 2 100k
R2 2 0 50k
RD 1 3 10
M1 3 2 0 0 MIRF520 W=1 L=1
.options reltol=1e-4 abstol=1e-12 vntol=1e-7
.control
set wr_singlescale
set wr_vecnames
option numdgt=7
op
wrdata salida.txt v(2) v(3) i(v1)
.endc
.end
