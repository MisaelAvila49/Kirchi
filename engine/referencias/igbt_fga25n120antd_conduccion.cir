* FGA25N120ANTD con 60 V y 2.3 ohm en el colector y 15 V en la compuerta: conduce unos 25 A
.include modelos.lib
V1 vin 0 DC 60
R1 vin c 2.3
V2 g 0 DC 15
M1 b g 0 0 MIGBT2 W=1 L=1
Q1 0 b ce QIGBT2
RE c ce 0.007178
D1 0 c DIGBT2
CGE g 0 3.62n
CGC g c 80p
CCE c 0 50p
.options reltol=1e-4 abstol=1e-12 vntol=1e-7
.control
set wr_singlescale
set wr_vecnames
option numdgt=7
op
wrdata salida.txt v(c) i(v1)
.endc
.end
