* Bufer 74HC244 a 4.5 V con sus dos habilitaciones y ocho datos en pulsos; las salidas pasan a alta impedancia
.model adc_0 adc_bridge(in_low=1.3499999999999999 in_high=3.15 rise_delay=1e-12 fall_delay=1e-12)
.model uno_d d_pullup(load=1e-12)
V1 n1 0 PULSE(0 4.5 0.000003 1e-12 1e-12 0.000001499999 0.000005999999999987999)
V2 n2 0 PULSE(0 4.5 0.000007 1e-12 1e-12 9.99999e-7 0.000009000000000008999)
V3 n3 0 PULSE(0 4.5 1e-7 1e-12 1e-12 3.09999e-7 6.200000000001736e-7)
V4 n4 0 PULSE(0 4.5 2.52e-7 1e-12 1e-12 6.169990000000001e-7 0.0000012339999999998149)
V5 n5 0 PULSE(0 4.5 5.91e-7 1e-12 1e-12 6.11999e-7 0.000001224000000000431)
V6 n6 0 PULSE(0 4.5 2.81e-7 1e-12 1e-12 6.199990000000001e-7 0.0000012400000000003473)
V7 n7 0 PULSE(0 4.5 3.45e-7 1e-12 1e-12 9.269990000000001e-7 0.000001854000000000319)
V8 n8 0 PULSE(0 4.5 6.29e-7 1e-12 1e-12 9.34999e-7 0.0000018699999999991958)
V9 n9 0 PULSE(0 4.5 9.79e-7 1e-12 1e-12 0.000001384999 0.0000027699999999993077)
V10 n10 0 PULSE(0 4.5 4.93e-7 1e-12 1e-12 0.000001392999 0.000002786000000001499)
AIN0 [n1] [d8] adc_0
AIN1 [n3] [d9] adc_0
AIN2 [n4] [d10] adc_0
AIN3 [n5] [d11] adc_0
AIN4 [n6] [d12] adc_0
AIN5 [n2] [d13] adc_0
AIN6 [n7] [d14] adc_0
AIN7 [n8] [d15] adc_0
AIN8 [n9] [d16] adc_0
AIN9 [n10] [d17] adc_0
*@generar lut u0 {"comunes":[],"rebanadas":[{"entradas":["d8","d9"],"salidas":["d0"]},{"entradas":["d8","d10"],"salidas":["d1"]},{"entradas":["d8","d11"],"salidas":["d2"]},{"entradas":["d8","d12"],"salidas":["d3"]},{"entradas":["d13","d14"],"salidas":["d4"]},{"entradas":["d13","d15"],"salidas":["d5"]},{"entradas":["d13","d16"],"salidas":["d6"]},{"entradas":["d13","d17"],"salidas":["d7"]}],"tabla":[0,1,2,2],"retardos":[[9.5e-9,9.5e-9]]}
.options reltol=1e-4 abstol=1e-12 vntol=1e-7 xtrtol=7
.control
set wr_singlescale
set wr_vecnames
option numdgt=7
tran 1n 12000n 0 0.1n uic
wrdata salida.txt v(n1)
eprint d0 d1 d2 d3 d4 d5 d6 d7 > eventos.txt
.endc
.end
