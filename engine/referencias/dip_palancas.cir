* Cuatro palancas de un interruptor DIP (r_on de 50 mohm, r_off de 1 Gohm) que se cierran en 20, 40, 60 y 80 us, cada una con un divisor de 1 kohm; ngspice las hace con una B de resistencia variable
V1 1 0 DC 5
VC0 c0 0 PWL(0 0 0.00002 0 0.000020000001 1 0.00015 1 0.00015000000099999998 0)
B0 1 m0 I=V(1,m0)/(1g+(0.05-1g)*V(c0))
R0 m0 0 1k
VC1 c1 0 PWL(0 0 0.00004 0 0.000040000001000000006 1)
B1 1 m1 I=V(1,m1)/(1g+(0.05-1g)*V(c1))
R1 m1 0 1k
VC2 c2 0 PWL(0 0 0.00006 0 0.000060000001000000004 1 0.00015 1 0.00015000000099999998 0)
B2 1 m2 I=V(1,m2)/(1g+(0.05-1g)*V(c2))
R2 m2 0 1k
VC3 c3 0 PWL(0 0 0.00008 0 0.000080000001 1)
B3 1 m3 I=V(1,m3)/(1g+(0.05-1g)*V(c3))
R3 m3 0 1k
.options reltol=1e-4 abstol=1e-12 vntol=1e-7
.control
set wr_singlescale
set wr_vecnames
option numdgt=7
tran 10n 200u 0 10n
wrdata salida.txt v(m0) v(m1) v(m2) v(m3)
.endc
.end
