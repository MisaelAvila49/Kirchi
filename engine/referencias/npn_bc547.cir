* Polarizacion de un NPN BC547 en emisor comun con divisor de base
.include modelos.lib
V1 1 0 DC 12
R1 1 2 47k
R2 2 0 10k
RC 1 3 2.2k
RE 4 0 470
Q1 3 2 4 QBC547
.options reltol=1e-4 abstol=1e-12 vntol=1e-7
.control
set wr_singlescale
set wr_vecnames
option numdgt=7
op
wrdata salida.txt v(2) v(3) v(4) i(v1)
.endc
.end
