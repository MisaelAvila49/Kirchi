* Decodificador 74HC138 a 4.5 V con las tres habilitaciones y el codigo en pulsos que se desfasan
.model adc_0 adc_bridge(in_low=1.3499999999999999 in_high=3.15 rise_delay=1e-12 fall_delay=1e-12)
.model uno_d d_pullup(load=1e-12)
V1 n1 0 PULSE(0 4.5 1e-7 1e-12 1e-12 0.000008999998999999999 0.000017999999999856)
V2 n2 0 PULSE(0 4.5 0.000004 1e-12 1e-12 8.99999e-7 0.00000580000000001508)
V3 n3 0 PULSE(0 4.5 0.0000025 1e-12 1e-12 0.000001299999 0.00000509999999998827)
V4 n4 0 PULSE(0 4.5 2.59e-7 1e-12 1e-12 0.000001199999 0.00000239999999999808)
V5 n5 0 PULSE(0 4.5 3.12e-7 1e-12 1e-12 5.99999e-7 0.00000120000000000048)
V6 n6 0 PULSE(0 4.5 0.000001762 1e-12 1e-12 2.99999e-7 0.0000023620000000011244)
AIN0 [n1] [d8] adc_0
AIN1 [n2] [d9] adc_0
AIN2 [n3] [d10] adc_0
AIN3 [n4] [d11] adc_0
AIN4 [n5] [d12] adc_0
AIN5 [n6] [d13] adc_0
*@generar lut u0 {"comunes":["d8","d9","d10","d11","d12","d13"],"rebanadas":[{"entradas":[],"salidas":["d0","d1","d2","d3","d4","d5","d6","d7"]}],"tabla":[21845,21845,21845,21845,21845,21845,21845,21845,21845,21845,21845,21845,21845,21845,21845,21845,21845,21845,21845,21845,21845,21845,21845,21845,21845,21845,21845,21845,21845,21845,21845,21845,21844,21841,21829,21781,21589,20821,17749,5461,21845,21845,21845,21845,21845,21845,21845,21845,21845,21845,21845,21845,21845,21845,21845,21845,21845,21845,21845,21845,21845,21845,21845,21845],"retardos":[[1.4499999999999999e-8,1.4499999999999999e-8],[1.4499999999999999e-8,1.4499999999999999e-8],[1.4499999999999999e-8,1.4499999999999999e-8],[1.4499999999999999e-8,1.4499999999999999e-8],[1.4499999999999999e-8,1.4499999999999999e-8],[1.4499999999999999e-8,1.4499999999999999e-8],[1.4499999999999999e-8,1.4499999999999999e-8],[1.4499999999999999e-8,1.4499999999999999e-8]]}
.options reltol=1e-4 abstol=1e-12 vntol=1e-7 xtrtol=7
.control
set wr_singlescale
set wr_vecnames
option numdgt=7
tran 1n 12000n 0 0.1n uic
wrdata salida.txt v(n1)
eprint d0 d1 d2 d3 d4 d5 d6 d7 > eventos.txt
.endc
.end
