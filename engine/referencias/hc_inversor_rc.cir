* Inversor 74HC a 5 V con carga RC: la rampa de la salida y su resistencia de 55 ohm
.include digital.lib
V1 in 0 PULSE(0 5 0 1p 1p 499.999n 1u)
AIN [in] [din] adc_hc5
AU1 din dout inv_hc5
AOUT [dout] [o1] dac_hc5
RO o1 out 55
R1 out c 1k
C1 c 0 100p
.options reltol=1e-4 abstol=1e-12 vntol=1e-7 xtrtol=7
.control
set wr_singlescale
set wr_vecnames
option numdgt=7
tran 1n 3u 0 0.1n uic
wrdata salida.txt v(out) v(c)
eprint din dout > eventos.txt
.endc
.end
