* Biestable JK 74HC en conmutacion (J = K = 1), por flanco de bajada como el 74HC112: XSPICE dispara en el de
* subida, asi que el reloj entra negado con 1 ps de retardo
.include digital.lib
VCK ck 0 PULSE(0 5 0 1p 1p 499.999n 1u)
ACK [ck] [dck] adc_hc5
AN dck nck inv_1ps
AUNO uno uno_d
ACERO cero cero_d
AU1 uno uno nck cero cero q qn jk_hc5
AOUT [q] [o1] dac_hc5
RO o1 out 55
R1 out 0 10k
.options reltol=1e-4 abstol=1e-12 vntol=1e-7 xtrtol=7
.control
set wr_singlescale
set wr_vecnames
option numdgt=7
tran 1n 5u 0 0.1n uic
wrdata salida.txt v(out)
eprint dck q qn > eventos.txt
.endc
.end
