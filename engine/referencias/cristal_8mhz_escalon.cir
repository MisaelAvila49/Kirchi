* Cristal de 8 MHz (rama motional de 19.7893 mH, 20 fF y 60 ohm con 4 pF en paralelo) con un escalon de 1 V por 50 ohm
V1 s 0 PULSE(0 1 0 1p 1p 1 2)
R1 s a 50
L1 a x 0.0197893
C1 x y 20f
R2 y 0 60
C0 a 0 4p
.options reltol=1e-4 abstol=1e-12 vntol=1e-7
.control
set wr_singlescale
set wr_vecnames
option numdgt=7
tran 1n 2u 0 1n uic
wrdata salida.txt v(a) i(v1)
.endc
.end
