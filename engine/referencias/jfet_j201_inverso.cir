* JFET J201 con el drenador y la fuente invertidos: VDS -1 V, VGS -0.2 V
.model JJ201 NJF(VTO=-0.67082 BETA=0.000993808 LAMBDA=0 IS=1e-14 N=1 PB=1 CGS=3.2e-12 CGD=5.2e-12 RD=0 RS=0)
V1 1 0 DC -1
VG 2 0 DC -0.2
J1 1 2 0 JJ201
.options reltol=1e-4 abstol=1e-12 vntol=1e-7
.control
set wr_singlescale
set wr_vecnames
option numdgt=7
op
wrdata salida.txt i(v1)
.endc
.end
