* Regulador con zener 1N4747A de 20 V (12.5 mA, 22 ohm)
.include modelos.lib
V1 1 0 DC 30
R1 1 2 470
D1 0 2 D1N4747A
RL 2 0 2.2k
.options reltol=1e-4 abstol=1e-12 vntol=1e-7
.control
set wr_singlescale
set wr_vecnames
option numdgt=7
op
wrdata salida.txt v(2) i(v1)
.endc
.end
