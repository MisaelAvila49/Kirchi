* Comparador 74LS85 a 5 V con A y B de cuatro bits y la cascada en pulsos
.model adc_0 adc_bridge(in_low=0.8 in_high=2 rise_delay=1e-12 fall_delay=1e-12)
.model uno_d d_pullup(load=1e-12)
V1 n1 0 PULSE(0 5 1e-7 1e-12 1e-12 4.999990000000001e-7 0.000001)
V2 n2 0 PULSE(0 5 1.53e-7 1e-12 1e-12 9.99999e-7 0.000002)
V3 n3 0 PULSE(0 5 8.5e-7 1e-12 1e-12 0.000002499999 0.000005)
V4 n4 0 PULSE(0 5 2.06e-7 1e-12 1e-12 0.000001999999 0.000004)
V5 n5 0 PULSE(0 5 2.59e-7 1e-12 1e-12 0.000002999999 0.000005999999999987999)
V6 n6 0 PULSE(0 5 3.05e-7 1e-12 1e-12 4.999990000000001e-7 0.000001)
V7 n7 0 PULSE(0 5 4.03e-7 1e-12 1e-12 9.99999e-7 0.000002)
V8 n8 0 PULSE(0 5 6.56e-7 1e-12 1e-12 0.000001999999 0.000004)
V9 n9 0 PULSE(0 5 7.59e-7 1e-12 1e-12 0.000002999999 0.000005999999999987999)
V10 n10 0 PULSE(0 5 5.24e-7 1e-12 1e-12 0.000002999999 0.000005999999999987999)
V11 n11 0 PULSE(0 5 6.98e-7 1e-12 1e-12 0.000001999999 0.000004)
AIN0 [n1] [d3] adc_0
AIN1 [n2] [d4] adc_0
AIN2 [n4] [d5] adc_0
AIN3 [n5] [d6] adc_0
AIN4 [n6] [d7] adc_0
AIN5 [n7] [d8] adc_0
AIN6 [n8] [d9] adc_0
AIN7 [n9] [d10] adc_0
AIN8 [n10] [d11] adc_0
AIN9 [n11] [d12] adc_0
AIN10 [n3] [d13] adc_0
*@generar lut u0 {"comunes":["d3","d4","d5","d6","d7","d8","d9","d10","d11","d12","d13"],"rebanadas":[{"entradas":[],"salidas":["d0","d1","d2"]}],"tabla":[17,16,4,4,1,0,4,4,1,1,1,1,1,1,1,1,1,1,1,1,1,1,1,1,1,1,1,1,1,1,1,1,1,1,1,1,1,1,1,1,1,1,1,1,1,1,1,1,1,1,1,1,1,1,1,1,1,1,1,1,1,1,1,1,1,1,1,1,1,1,1,1,1,1,1,1,1,1,1,1,1,1,1,1,1,1,1,1,1,1,1,1,1,1,1,1,1,1,1,1,1,1,1,1,1,1,1,1,1,1,1,1,1,1,1,1,1,1,1,1,1,1,1,1,1,1,1,1,16,16,16,16,16,16,16,16,17,16,4,4,1,0,4,4,16,16,16,16,16,16,16,16,1,1,1,1,1,1,1,1,16,16,16,16,16,16,16,16,1,1,1,1,1,1,1,1,16,16,16,16,16,16,16,16,1,1,1,1,1,1,1,1,16,16,16,16,16,16,16,16,1,1,1,1,1,1,1,1,16,16,16,16,16,16,16,16,1,1,1,1,1,1,1,1,16,16,16,16,16,16,16,16,1,1,1,1,1,1,1,1,16,16,16,16,16,16,16,16,1,1,1,1,1,1,1,1,16,16,16,16,16,16,16,16,1,1,1,1,1,1,1,1,17,16,4,4,1,0,4,4,1,1,1,1,1,1,1,1,16,16,16,16,16,16,16,16,1,1,1,1,1,1,1,1,1,1,1,1,1,1,1,1,1,1,1,1,1,1,1,1,16,16,16,16,16,16,16,16,1,1,1,1,1,1,1,1,1,1,1,1,1,1,1,1,1,1,1,1,1,1,1,1,16,16,16,16,16,16,16,16,1,1,1,1,1,1,1,1,1,1,1,1,1,1,1,1,1,1,1,1,1,1,1,1,16,16,16,16,16,16,16,16,16,16,16,16,16,16,16,16,16,16,16,16,16,16,16,16,17,16,4,4,1,0,4,4,16,16,16,16,16,16,16,16,16,16,16,16,16,16,16,16,16,16,16,16,16,16,16,16,1,1,1,1,1,1,1,1,16,16,16,16,16,16,16,16,16,16,16,16,16,16,16,16,16,16,16,16,16,16,16,16,1,1,1,1,1,1,1,1,16,16,16,16,16,16,16,16,16,16,16,16,16,16,16,16,16,16,16,16,16,16,16,16,1,1,1,1,1,1,1,1,16,16,16,16,16,16,16,16,1,1,1,1,1,1,1,1,1,1,1,1,1,1,1,1,1,1,1,1,1,1,1,1,17,16,4,4,1,0,4,4,1,1,1,1,1,1,1,1,1,1,1,1,1,1,1,1,1,1,1,1,1,1,1,1,16,16,16,16,16,16,16,16,1,1,1,1,1,1,1,1,1,1,1,1,1,1,1,1,1,1,1,1,1,1,1,1,1,1,1,1,1,1,1,1,1,1,1,1,1,1,1,1,1,1,1,1,1,1,1,1,1,1,1,1,1,1,1,1,16,16,16,16,16,16,16,16,16,16,16,16,16,16,16,16,16,16,16,16,16,16,16,16,1,1,1,1,1,1,1,1,16,16,16,16,16,16,16,16,17,16,4,4,1,0,4,4,16,16,16,16,16,16,16,16,1,1,1,1,1,1,1,1,16,16,16,16,16,16,16,16,16,16,16,16,16,16,16,16,16,16,16,16,16,16,16,16,1,1,1,1,1,1,1,1,16,16,16,16,16,16,16,16,1,1,1,1,1,1,1,1,16,16,16,16,16,16,16,16,1,1,1,1,1,1,1,1,16,16,16,16,16,16,16,16,1,1,1,1,1,1,1,1,16,16,16,16,16,16,16,16,1,1,1,1,1,1,1,1,16,16,16,16,16,16,16,16,1,1,1,1,1,1,1,1,17,16,4,4,1,0,4,4,1,1,1,1,1,1,1,1,16,16,16,16,16,16,16,16,1,1,1,1,1,1,1,1,16,16,16,16,16,16,16,16,1,1,1,1,1,1,1,1,16,16,16,16,16,16,16,16,1,1,1,1,1,1,1,1,1,1,1,1,1,1,1,1,1,1,1,1,1,1,1,1,16,16,16,16,16,16,16,16,16,16,16,16,16,16,16,16,16,16,16,16,16,16,16,16,16,16,16,16,16,16,16,16,16,16,16,16,16,16,16,16,16,16,16,16,16,16,16,16,16,16,16,16,16,16,16,16,17,16,4,4,1,0,4,4,16,16,16,16,16,16,16,16,16,16,16,16,16,16,16,16,16,16,16,16,16,16,16,16,16,16,16,16,16,16,16,16,16,16,16,16,16,16,16,16,16,16,16,16,16,16,16,16,16,16,16,16,16,16,16,16,1,1,1,1,1,1,1,1,16,16,16,16,16,16,16,16,1,1,1,1,1,1,1,1,1,1,1,1,1,1,1,1,1,1,1,1,1,1,1,1,1,1,1,1,1,1,1,1,1,1,1,1,1,1,1,1,1,1,1,1,1,1,1,1,1,1,1,1,1,1,1,1,17,16,4,4,1,0,4,4,1,1,1,1,1,1,1,1,1,1,1,1,1,1,1,1,1,1,1,1,1,1,1,1,1,1,1,1,1,1,1,1,1,1,1,1,1,1,1,1,1,1,1,1,1,1,1,1,1,1,1,1,1,1,1,1,16,16,16,16,16,16,16,16,16,16,16,16,16,16,16,16,16,16,16,16,16,16,16,16,1,1,1,1,1,1,1,1,16,16,16,16,16,16,16,16,1,1,1,1,1,1,1,1,16,16,16,16,16,16,16,16,1,1,1,1,1,1,1,1,16,16,16,16,16,16,16,16,17,16,4,4,1,0,4,4,16,16,16,16,16,16,16,16,1,1,1,1,1,1,1,1,16,16,16,16,16,16,16,16,1,1,1,1,1,1,1,1,16,16,16,16,16,16,16,16,1,1,1,1,1,1,1,1,16,16,16,16,16,16,16,16,1,1,1,1,1,1,1,1,16,16,16,16,16,16,16,16,1,1,1,1,1,1,1,1,16,16,16,16,16,16,16,16,1,1,1,1,1,1,1,1,1,1,1,1,1,1,1,1,1,1,1,1,1,1,1,1,16,16,16,16,16,16,16,16,1,1,1,1,1,1,1,1,17,16,4,4,1,0,4,4,1,1,1,1,1,1,1,1,16,16,16,16,16,16,16,16,1,1,1,1,1,1,1,1,1,1,1,1,1,1,1,1,1,1,1,1,1,1,1,1,16,16,16,16,16,16,16,16,16,16,16,16,16,16,16,16,16,16,16,16,16,16,16,16,16,16,16,16,16,16,16,16,16,16,16,16,16,16,16,16,16,16,16,16,16,16,16,16,16,16,16,16,16,16,16,16,1,1,1,1,1,1,1,1,16,16,16,16,16,16,16,16,16,16,16,16,16,16,16,16,16,16,16,16,16,16,16,16,17,16,4,4,1,0,4,4,16,16,16,16,16,16,16,16,16,16,16,16,16,16,16,16,16,16,16,16,16,16,16,16,1,1,1,1,1,1,1,1,16,16,16,16,16,16,16,16,1,1,1,1,1,1,1,1,1,1,1,1,1,1,1,1,1,1,1,1,1,1,1,1,16,16,16,16,16,16,16,16,1,1,1,1,1,1,1,1,1,1,1,1,1,1,1,1,1,1,1,1,1,1,1,1,16,16,16,16,16,16,16,16,1,1,1,1,1,1,1,1,1,1,1,1,1,1,1,1,1,1,1,1,1,1,1,1,17,16,4,4,1,0,4,4,1,1,1,1,1,1,1,1,1,1,1,1,1,1,1,1,1,1,1,1,1,1,1,1,16,16,16,16,16,16,16,16,16,16,16,16,16,16,16,16,16,16,16,16,16,16,16,16,1,1,1,1,1,1,1,1,16,16,16,16,16,16,16,16,16,16,16,16,16,16,16,16,16,16,16,16,16,16,16,16,1,1,1,1,1,1,1,1,16,16,16,16,16,16,16,16,16,16,16,16,16,16,16,16,16,16,16,16,16,16,16,16,1,1,1,1,1,1,1,1,16,16,16,16,16,16,16,16,17,16,4,4,1,0,4,4,16,16,16,16,16,16,16,16,1,1,1,1,1,1,1,1,16,16,16,16,16,16,16,16,1,1,1,1,1,1,1,1,16,16,16,16,16,16,16,16,1,1,1,1,1,1,1,1,16,16,16,16,16,16,16,16,1,1,1,1,1,1,1,1,16,16,16,16,16,16,16,16,1,1,1,1,1,1,1,1,16,16,16,16,16,16,16,16,1,1,1,1,1,1,1,1,16,16,16,16,16,16,16,16,1,1,1,1,1,1,1,1,16,16,16,16,16,16,16,16,1,1,1,1,1,1,1,1,17,16,4,4,1,0,4,4,1,1,1,1,1,1,1,1,16,16,16,16,16,16,16,16,16,16,16,16,16,16,16,16,16,16,16,16,16,16,16,16,16,16,16,16,16,16,16,16,16,16,16,16,16,16,16,16,16,16,16,16,16,16,16,16,16,16,16,16,16,16,16,16,16,16,16,16,16,16,16,16,16,16,16,16,16,16,16,16,16,16,16,16,16,16,16,16,16,16,16,16,16,16,16,16,16,16,16,16,16,16,16,16,16,16,16,16,16,16,16,16,16,16,16,16,16,16,16,16,16,16,16,16,16,16,16,16,17,16,4,4,1,0,4,4],"retardos":[[1.8e-8,1.7e-8],[2.1000000000000003e-8,1.9999999999999997e-8],[1.8e-8,1.7e-8]]}
.options reltol=1e-4 abstol=1e-12 vntol=1e-7 xtrtol=7
.control
set wr_singlescale
set wr_vecnames
option numdgt=7
tran 1n 12000n 0 0.1n uic
wrdata salida.txt v(n1)
eprint d0 d1 d2 > eventos.txt
.endc
.end
