* Contador Johnson 74HC4017 a 5 V con INH, reloj y borrado al azar
.model adc_0 adc_bridge(in_low=1.5 in_high=3.5 rise_delay=1e-12 fall_delay=1e-12)
V1 n1 0 PWL(0 0 3e-7 0 3.000001e-7 5 8e-7 5 8.000001e-7 0 0.0000013 0 0.0000013000001 5 0.0000018 5 0.0000018000001 0 0.0000023 0 0.0000023000001000000004 5 0.0000028 5 0.0000028000001000000002 0 0.0000033 0 0.0000033000001 5 0.0000038 5 0.0000038000001000000004 0 0.0000043 0 0.0000043000001 5 0.0000048 5 0.0000048000001000000006 0 0.0000053 0 0.0000053000001 5 0.0000058 5 0.0000058000001 0 0.0000063 0 0.000006300000100000001 5 0.0000068 5 0.0000068000001 0 0.0000073 0 0.0000073000001 5 0.0000078 5 0.0000078000001 0 0.0000083 0 0.0000083000001 5 0.0000088 5 0.000008800000099999999 0 0.0000093 0 0.000009300000099999999 5 0.0000098 5 0.0000098000001 0 0.0000103 0 0.0000103000001 5 0.0000108 5 0.0000108000001 0 0.0000113 0 0.000011300000099999998 5 0.0000118 5 0.000011800000099999999 0 0.0000123 0 0.000012300000099999999 5 0.0000128 5 0.0000128000001 0 0.0000133 0 0.0000133000001 5 0.0000138 5 0.0000138000001 0 0.0000143 0 0.000014300000099999999 5 0.0000148 5 0.000014800000099999999 0 0.0000153 0 0.0000153000001 5 0.0000158 5 0.0000158000001 0 0.0000163 0 0.000016300000099999998 5 0.0000168 5 0.0000168000001 0 0.0000173 0 0.000017300000100000002 5 0.0000178 5 0.0000178000001 0 0.0000183 0 0.000018300000100000003 5 0.0000188 5 0.0000188000001 0 0.0000193 0 0.0000193000001 5 0.0000198 5 0.000019800000100000002 0 0.0000203 0 0.0000203000001 5 0.0000208 5 0.000020800000100000002 0 0.0000213 0 0.0000213000001 5 0.0000218 5 0.0000218000001 0 0.0000223 0 0.0000223000001 5 0.0000228 5 0.0000228000001 0 0.0000233 0 0.000023300000100000002 5 0.0000238 5 0.0000238000001 0 0.0000243 0 0.000024300000100000003 5 0.0000248 5 0.0000248000001 0 0.0000253 0 0.0000253000001 5 0.0000258 5 0.000025800000100000002 0 0.0000263 0 0.0000263000001 5 0.0000268 5 0.000026800000100000003 0 0.0000273 0 0.0000273000001 5 0.0000278 5 0.0000278000001 0 0.0000283 0 0.000028300000100000002 5 0.0000288 5 0.0000288000001 0 0.0000293 0 0.000029300000100000002 5 0.0000298 5 0.0000298000001 0 0.0000303 0 0.0000303000001 5 0.0000308 5 0.0000308000001 0 0.0000313 0 0.0000313000001 5 0.0000318 5 0.0000318000001 0 0.0000323 0 0.000032300000100000004 5 0.0000328 5 0.000032800000099999996 0 0.0000333 0 0.000033300000099999995 5 0.0000338 5 0.0000338000001 0 0.0000343 0 0.0000343000001 5 0.0000348 5 0.0000348000001 0 0.0000353 0 0.000035300000099999996 5 0.0000358 5 0.000035800000099999994 0 0.0000363 0 0.0000363000001 5 0.0000368 5 0.0000368000001 0 0.0000373 0 0.0000373000001 5 0.0000378 5 0.000037800000099999995 0 0.0000383 0 0.0000383000001 5 0.0000388 5 0.0000388000001 0 0.0000393 0 0.0000393000001 5 0.0000398 5 0.0000398000001 0 0.0000403 0 0.000040300000099999995 5 0.0000408 5 0.0000408000001 0 0.0000413 0 0.0000413000001 5 0.0000418 5 0.0000418000001 0 0.0000423 0 0.000042300000099999996 5 0.0000428 5 0.000042800000099999995 0 0.0000433 0 0.0000433000001 5 0.0000438 5 0.0000438000001 0 0.0000443 0 0.0000443000001 5 0.0000448 5 0.000044800000099999996 0 0.0000453 0 0.000045300000099999995 5 0.0000458 5 0.0000458000001 0 0.0000463 0 0.0000463000001 5 0.0000468 5 0.0000468000001 0 0.0000473 0 0.000047300000099999996 5 0.0000478 5 0.000047800000099999995 0 0.0000483 0 0.0000483000001 5 0.0000488 5 0.0000488000001 0 0.0000493 0 0.0000493000001 5 0.0000498 5 0.000049800000099999996 0 0.0000503 0 0.000050300000099999994 5 0.0000508 5 0.0000508000001 0 0.0000513 0 0.0000513000001 5 0.0000518 5 0.0000518000001 0 0.0000523 0 0.000052300000099999996 5 0.0000528 5 0.000052800000099999994 0 0.0000533 0 0.0000533000001 5 0.0000538 5 0.0000538000001 0 0.0000543 0 0.0000543000001 5 0.0000548 5 0.000054800000099999995 0 0.0000553 0 0.0000553000001 5 0.0000558 5 0.0000558000001 0 0.0000563 0 0.0000563000001 5 0.0000568 5 0.000056800000099999997 0 0.0000573 0 0.000057300000099999995 5 0.0000578 5 0.0000578000001 0 0.0000583 0 0.0000583000001 5 0.0000588 5 0.0000588000001 0 0.0000593 0 0.000059300000099999996 5 0.0000598 5 0.000059800000099999995 0)
V2 n2 0 PWL(0 0 0.0000045 0 0.0000045000001 5 0.0000047 5 0.0000047000001 0 0.0000065 0 0.0000065000001 5 0.0000067 5 0.0000067000001 0 0.0000085 0 0.0000085000001 5 0.0000087 5 0.0000087000001 0 0.0000225 0 0.0000225000001 5 0.0000227 5 0.0000227000001 0 0.0000255 0 0.0000255000001 5 0.0000257 5 0.0000257000001 0 0.0000285 0 0.0000285000001 5 0.0000287 5 0.0000287000001 0 0.0000325 0 0.0000325000001 5 0.0000327 5 0.0000327000001 0 0.0000335 0 0.0000335000001 5 0.0000337 5 0.0000337000001 0 0.0000365 0 0.0000365000001 5 0.0000367 5 0.000036700000099999996 0 0.0000375 0 0.000037500000099999995 5 0.0000377 5 0.0000377000001 0 0.0000415 0 0.0000415000001 5 0.0000417 5 0.000041700000099999995 0 0.0000435 0 0.0000435000001 5 0.0000437 5 0.000043700000099999997 0 0.0000565 0 0.000056500000099999996 5 0.0000567 5 0.000056700000099999994 0)
V3 n3 0 PWL(0 0 0.00000285 0 0.0000028500001 5 0.00000295 5 0.0000029500001 0 0.00005685 0 0.0000568500001 5 0.00005695 5 0.0000569500001 0 0.00005885 0 0.0000588500001 5 0.00005895 5 0.000058950000099999995 0)
AIN0 [n1] [d11] adc_0
AIN1 [n2] [d12] adc_0
AIN2 [n3] [d13] adc_0
*@generar msi u0 {"entradas":["d11","d12","d13"],"salidas":["d0","d1","d2","d3","d4","d5","d6","d7","d8","d9","d10"],"nucleo":{"tipo":"contador","bits":4,"modulo":10,"reloj":{"senales":[{"entrada":0},{"entrada":1,"bajo":true}],"combina":"Y","flanco":"subida"},"borra":{"senal":{"entrada":2},"sincrona":false}},"de":[{"tipo":"tabla","columna":0},{"tipo":"tabla","columna":1},{"tipo":"tabla","columna":2},{"tipo":"tabla","columna":3},{"tipo":"tabla","columna":4},{"tipo":"tabla","columna":5},{"tipo":"tabla","columna":6},{"tipo":"tabla","columna":7},{"tipo":"tabla","columna":8},{"tipo":"tabla","columna":9},{"tipo":"tabla","columna":10}],"fuentes":[{"bit":3},{"bit":2},{"bit":1},{"bit":0}],"tabla":[1048577,1048580,1048592,1048640,1048832,1024,4096,16384,65536,262144,0,0,0,0,0,0],"retardos":[[1.5666666666666668e-8,1.5666666666666668e-8],[1.5666666666666668e-8,1.5666666666666668e-8],[1.5666666666666668e-8,1.5666666666666668e-8],[1.5666666666666668e-8,1.5666666666666668e-8],[1.5666666666666668e-8,1.5666666666666668e-8],[1.5666666666666668e-8,1.5666666666666668e-8],[1.5666666666666668e-8,1.5666666666666668e-8],[1.5666666666666668e-8,1.5666666666666668e-8],[1.5666666666666668e-8,1.5666666666666668e-8],[1.5666666666666668e-8,1.5666666666666668e-8],[1.5666666666666668e-8,1.5666666666666668e-8]]}
.options reltol=1e-4 abstol=1e-12 vntol=1e-7 xtrtol=7
.control
set wr_singlescale
set wr_vecnames
option numdgt=7
tran 1n 60000n 0 0.1n uic
wrdata salida.txt v(n1)
eprint d0 d1 d2 d3 d4 d5 d6 d7 d8 d9 d10 > eventos.txt
.endc
.end
