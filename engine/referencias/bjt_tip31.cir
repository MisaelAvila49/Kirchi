* NPN TIP31 en emisor comun con unos 0.8 A
.include modelos.lib
V1 1 0 DC 12
RB 1 2 680
RC 1 3 10
Q1 3 2 0 QTIP31
.options reltol=1e-4 abstol=1e-12 vntol=1e-7
.control
set wr_singlescale
set wr_vecnames
option numdgt=7
op
wrdata salida.txt v(2) v(3) i(v1)
.endc
.end
