* Contador de 4 bits 74HC que cuenta hasta 9 con reloj de 1 MHz; el reinicio asincrono esta activo en el primer
* 0.75 us y de nuevo de 12.4 a 13.15 us, sin coincidir con un flanco del reloj
.include digital.lib
VCK ck 0 PULSE(0 5 0 1p 1p 499.999n 1u)
VR r 0 PULSE(0 5 0 1p 1p 0.749999u 12.4u)
AIN [ck r] [dck dr] adc_hc5
ACERO cero cero_d
AU1 [cero] dck dr [q3 q2 q1 q0 co] cuenta10_hc5
AOUT [co] [o1] dac_hc5
RO o1 out 55
R1 out 0 10k
.options reltol=1e-4 abstol=1e-12 vntol=1e-7 xtrtol=7
.control
set wr_singlescale
set wr_vecnames
option numdgt=7
tran 1n 16u 0 0.1n uic
wrdata salida.txt v(out)
eprint dck dr q0 q1 q2 q3 co > eventos.txt
.endc
.end
