* Diente de sierra de 1 kHz (simetria de 100 %: sube en todo el periodo y baja de golpe), 2 Vpp, 50 ohm sobre 1 kohm
V1 1 0 PULSE(-1 1 0 0.999999999m 1p 0 1m)
RS 1 2 50
RL 2 0 1k
.options reltol=1e-4 abstol=1e-12 vntol=1e-7
.control
set wr_singlescale
set wr_vecnames
option numdgt=7
tran 2u 2.5m 0 1u uic
wrdata salida.txt v(2) i(v1)
.endc
.end
