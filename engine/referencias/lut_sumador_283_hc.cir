* Sumador 74HC283 a 5 V con A, B y el acarreo de entrada en pulsos de periodos distintos
.model adc_0 adc_bridge(in_low=1.5 in_high=3.5 rise_delay=1e-12 fall_delay=1e-12)
.model uno_d d_pullup(load=1e-12)
V1 n1 0 PULSE(0 5 1e-7 1e-12 1e-12 3.1999900000000003e-7 6.4e-7)
V2 n2 0 PULSE(0 5 1.53e-7 1e-12 1e-12 6.39999e-7 0.00000128)
V3 n3 0 PULSE(0 5 2.06e-7 1e-12 1e-12 0.000001279999 0.00000256)
V4 n4 0 PULSE(0 5 2.59e-7 1e-12 1e-12 0.000002559999 0.00000512)
V5 n5 0 PULSE(0 5 3.56e-7 1e-12 1e-12 6.35999e-7 0.0000012719999999993182)
V6 n6 0 PULSE(0 5 4.2e-7 1e-12 1e-12 9.59999e-7 0.000001920000000001229)
V7 n7 0 PULSE(0 5 4.62e-7 1e-12 1e-12 0.000001919999 0.000003839999999995084)
V8 n8 0 PULSE(0 5 5.04e-7 1e-12 1e-12 0.000003839998999999999 0.00000768000000001966)
V9 n9 0 PULSE(0 5 6.01e-7 1e-12 1e-12 0.000001167999 0.000002335999999999028)
AIN0 [n1] [d5] adc_0
AIN1 [n2] [d6] adc_0
AIN2 [n3] [d7] adc_0
AIN3 [n4] [d8] adc_0
AIN4 [n5] [d9] adc_0
AIN5 [n6] [d10] adc_0
AIN6 [n7] [d11] adc_0
AIN7 [n8] [d12] adc_0
AIN8 [n9] [d13] adc_0
*@generar lut u0 {"comunes":["d5","d6","d7","d8","d9","d10","d11","d12","d13"],"rebanadas":[{"entradas":[],"salidas":["d0","d1","d2","d3","d4"]}],"tabla":[0,1,64,65,16,17,80,81,4,5,68,69,20,21,84,85,1,4,65,68,17,20,81,84,5,16,69,80,21,64,85,256,64,65,256,257,80,81,272,273,68,69,260,261,84,85,276,277,65,68,257,260,81,84,273,276,69,80,261,272,85,256,277,320,16,17,80,81,64,65,256,257,20,21,84,85,68,69,260,261,17,20,81,84,65,68,257,260,21,64,85,256,69,80,261,272,80,81,272,273,256,257,320,321,84,85,276,277,260,261,324,325,81,84,273,276,257,260,321,324,85,256,277,320,261,272,325,336,4,5,68,69,20,21,84,85,16,17,80,81,64,65,256,257,5,16,69,80,21,64,85,256,17,20,81,84,65,68,257,260,68,69,260,261,84,85,276,277,80,81,272,273,256,257,320,321,69,80,261,272,85,256,277,320,81,84,273,276,257,260,321,324,20,21,84,85,68,69,260,261,64,65,256,257,80,81,272,273,21,64,85,256,69,80,261,272,65,68,257,260,81,84,273,276,84,85,276,277,260,261,324,325,256,257,320,321,272,273,336,337,85,256,277,320,261,272,325,336,257,260,321,324,273,276,337,340,1,4,65,68,17,20,81,84,5,16,69,80,21,64,85,256,4,5,68,69,20,21,84,85,16,17,80,81,64,65,256,257,65,68,257,260,81,84,273,276,69,80,261,272,85,256,277,320,68,69,260,261,84,85,276,277,80,81,272,273,256,257,320,321,17,20,81,84,65,68,257,260,21,64,85,256,69,80,261,272,20,21,84,85,68,69,260,261,64,65,256,257,80,81,272,273,81,84,273,276,257,260,321,324,85,256,277,320,261,272,325,336,84,85,276,277,260,261,324,325,256,257,320,321,272,273,336,337,5,16,69,80,21,64,85,256,17,20,81,84,65,68,257,260,16,17,80,81,64,65,256,257,20,21,84,85,68,69,260,261,69,80,261,272,85,256,277,320,81,84,273,276,257,260,321,324,80,81,272,273,256,257,320,321,84,85,276,277,260,261,324,325,21,64,85,256,69,80,261,272,65,68,257,260,81,84,273,276,64,65,256,257,80,81,272,273,68,69,260,261,84,85,276,277,85,256,277,320,261,272,325,336,257,260,321,324,273,276,337,340,256,257,320,321,272,273,336,337,260,261,324,325,276,277,340,341],"retardos":[[1.4666666666666666e-8,1.4666666666666666e-8],[1.4666666666666666e-8,1.4666666666666666e-8],[1.4666666666666666e-8,1.4666666666666666e-8],[1.4666666666666666e-8,1.4666666666666666e-8],[1.2666666666666668e-8,1.2666666666666668e-8]]}
.options reltol=1e-4 abstol=1e-12 vntol=1e-7 xtrtol=7
.control
set wr_singlescale
set wr_vecnames
option numdgt=7
tran 1n 12000n 0 0.1n uic
wrdata salida.txt v(n1)
eprint d0 d1 d2 d3 d4 > eventos.txt
.endc
.end
