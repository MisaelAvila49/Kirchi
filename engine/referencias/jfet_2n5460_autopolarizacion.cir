* Autopolarizacion de un JFET 2N5460 de canal P con resistencia en la fuente
.model J2N5460 PJF(VTO=-2.12132 BETA=0.000496904 LAMBDA=0 IS=1e-14 N=1 PB=1 CGS=5e-12 CGD=8e-12 RD=0 RS=0)
V1 1 0 DC 15
RG 2 0 1Meg
RS 1 3 1k
RD 4 0 2.2k
J1 4 2 3 J2N5460
.options reltol=1e-4 abstol=1e-12 vntol=1e-7
.control
set wr_singlescale
set wr_vecnames
option numdgt=7
op
wrdata salida.txt v(3) v(4) i(v1)
.endc
.end
