* JFET J175 de canal P que conmuta una carga de 100 ohm con un pulso de compuerta
.model JJ175 PJF(VTO=-4.5 BETA=0.00101204 LAMBDA=0 IS=1e-14 N=1 PB=1 CGS=1.6734e-11 CGD=1.3266e-11 RD=0 RS=0)
V1 1 0 DC -12
V2 4 0 PULSE(0 6 20u 1n 1n 49.998u 100u)
RG 4 2 1k
RL 1 3 100
J1 3 2 0 JJ175
.options reltol=1e-4 abstol=1e-12 vntol=1e-7
.control
set wr_singlescale
set wr_vecnames
option numdgt=7
tran 0.1u 300u 5u 20n uic
wrdata salida.txt v(2) v(3) i(v1)
.endc
.end
