* MOSFET 2N7000 que conmuta una carga de 100 ohm
.include modelos.lib
V1 1 0 DC 12
VG 4 0 PULSE(0 5 0 1p 1p 49.999999u 100u)
RG 4 2 1k
RD 1 3 100
M1 3 2 0 0 M2N7000 W=1 L=1
.options reltol=1e-4 abstol=1e-12 vntol=1e-7
.control
set wr_singlescale
set wr_vecnames
option numdgt=7
tran 0.1u 300u 0 20n uic
let idd = -i(v1)
wrdata salida.txt v(2) v(3) i(v1) idd
.endc
.end
