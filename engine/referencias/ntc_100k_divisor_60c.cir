* Divisor de 5 V con 100 kOhm y el NTC de 100 kOhm de Vishay a 60 C (tabla R/T)
*@generar termistor tm1 {"tipo":"ntc","r25":100000,"beta":4190,"rt":[[-40,3666000],[-35,2638000],[-30,1917000],[-25,1406000],[-20,1041000],[-15,777800],[-10,586100],[-5,445300],[0,340900],[5,263100],[10,204400],[15,160000],[20,126100],[25,100000],[30,79810],[35,64080],[40,51750],[45,42020],[50,34310],[55,28160],[60,23220],[65,19250],[70,16020],[75,13400],[80,11260],[85,9496],[90,8042],[95,6837],[100,5835],[105,4998],[110,4296],[115,3705],[120,3206],[125,2783],[130,2423],[135,2116],[140,1854],[145,1628],[150,1434]],"delta":0.007,"tau":15}
V1 1 0 DC 5
R1 1 2 100k
X1 2 0 tm1 amb=60
.options reltol=1e-4 abstol=1e-12 vntol=1e-7
.control
set wr_singlescale
set wr_vecnames
option numdgt=7
op
wrdata salida.txt v(2) i(v1)
.endc
.end
