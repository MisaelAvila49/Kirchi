* Amperimetro de 0.1 ohm (90 mohm y el fusible de 10 mohm) en serie con 10 ohm a 5 V
V1 1 0 DC 5
VP n1 2 DC 0
RM n1 n2 0.09
RF n2 1 10m
RL 2 0 10
.options reltol=1e-4 abstol=1e-12 vntol=1e-7
.control
set wr_singlescale
set wr_vecnames
option numdgt=7
op
wrdata salida.txt v(2) i(vp)
.endc
.end
