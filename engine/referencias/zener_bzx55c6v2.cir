* Regulador con zener BZX55C6V2 (5 mA, 10 ohm)
.include modelos.lib
V1 1 0 DC 12
R1 1 2 470
D1 0 2 DBZX55C6V2
RL 2 0 1k
.options reltol=1e-4 abstol=1e-12 vntol=1e-7
.control
set wr_singlescale
set wr_vecnames
option numdgt=7
op
wrdata salida.txt v(2) i(v1)
.endc
.end
