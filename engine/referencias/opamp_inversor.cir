* Inversor de ganancia 10 con LM741 que satura
.include modelos.lib
V1 1 0 DC 15
V2 2 0 DC -15
VIN 3 0 SIN(0 1.5 500)
RI 3 4 1k
RF 4 5 10k
RL 5 0 10k
XU1 0 4 5 1 2 AMPOP a0=2e5 gbw=1e6 sr=0.5e6 rin=2e6 rout=75 ilim=25m dhi=1 dlo=1 rq=17.6k
.options reltol=1e-4 abstol=1e-12 vntol=1e-7
.control
set wr_singlescale
set wr_vecnames
option numdgt=7
tran 4u 4m 0 1u uic
let isal = -(v(5)-v(4))/10k - v(5)/10k
let ivp = -i(v1)
let ivn = -i(v2)
wrdata salida.txt v(4) v(5) i(v1) isal ivp ivn
.endc
.end
