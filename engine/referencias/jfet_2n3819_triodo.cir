* JFET 2N3819 en la region lineal: VDS 0.5 V, VGS -1 V
.model J2N3819 NJF(VTO=-3.63636 BETA=0.000727891 LAMBDA=0.0025974 IS=1e-14 N=1 PB=1 CGS=1.5e-12 CGD=2.8e-12 RD=0 RS=0)
V1 1 0 DC 0.5
VG 2 0 DC -1
J1 1 2 0 J2N3819
.options reltol=1e-4 abstol=1e-12 vntol=1e-7
.control
set wr_singlescale
set wr_vecnames
option numdgt=7
op
wrdata salida.txt i(v1)
.endc
.end
