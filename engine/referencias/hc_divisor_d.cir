* Biestable D 74HC como divisor entre dos: Q negada a D, PRE y CLR inactivos
.include digital.lib
VCK ck 0 PULSE(0 5 0 1p 1p 499.999n 1u)
ACK [ck] [dck] adc_hc5
ACERO cero cero_d
AU1 qn dck cero cero q qn dff_hc5
AOUT [q] [o1] dac_hc5
RO o1 out 55
R1 out 0 10k
.options reltol=1e-4 abstol=1e-12 vntol=1e-7 xtrtol=7
.control
set wr_singlescale
set wr_vecnames
option numdgt=7
tran 1n 5u 0 0.1n uic
wrdata salida.txt v(out)
eprint dck q qn > eventos.txt
.endc
.end
