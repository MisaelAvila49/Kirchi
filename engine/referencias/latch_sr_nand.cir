* Latch SR de dos NAND 74HC con las dos entradas (activas en bajo) soltadas a la vez a los 50 ns: con retardos
* iguales las dos salidas oscilan juntas cada 5 ns, como en XSPICE
.include digital.lib
VS s 0 PULSE(0 5 50n 1p 1p 1 2)
AS [s] [ds] adc_hc5
AU1 [ds qb] q nand_hc5
AU2 [ds q] qb nand_hc5
AOUT [q] [o1] dac_hc5
RO o1 out 55
R1 out 0 10k
.options reltol=1e-4 abstol=1e-12 vntol=1e-7 xtrtol=7
.control
set wr_singlescale
set wr_vecnames
option numdgt=7
tran 1n 200n 0 0.1n uic
wrdata salida.txt v(out)
eprint ds q qb > eventos.txt
.endc
.end
