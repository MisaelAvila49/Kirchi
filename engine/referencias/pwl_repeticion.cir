* Triangular de 3 ms que se repite con r=0, sobre una resistencia y un capacitor
V1 1 0 PWL(0 0 0.001 5 0.002 0 0.003 0) r=0
R1 1 2 1k
C1 2 0 100n
.options reltol=1e-4 abstol=1e-12 vntol=1e-7
.control
set wr_singlescale
set wr_vecnames
option numdgt=7
tran 10u 10m 0 2u uic
wrdata salida.txt v(1) v(2) i(v1)
.endc
.end
