* IRG4BC30UD con 30 V y 2.3 ohm en el colector y 15 V en la compuerta: conduce unos 12 A
.include modelos.lib
V1 vin 0 DC 30
R1 vin c 2.3
V2 g 0 DC 15
M1 b g 0 0 MIGBT1 W=1 L=1
Q1 0 b ce QIGBT1
RE c ce 0.016174
D1 0 c DIGBT1
CGE g 0 1.086n
CGC g c 14p
CCE c 0 59p
.options reltol=1e-4 abstol=1e-12 vntol=1e-7
.control
set wr_singlescale
set wr_vecnames
option numdgt=7
op
wrdata salida.txt v(c) i(v1)
.endc
.end
