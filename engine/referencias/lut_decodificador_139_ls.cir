* Un decodificador 74LS139 a 5 V con su habilitacion y el codigo en pulsos
.model adc_0 adc_bridge(in_low=0.8 in_high=2 rise_delay=1e-12 fall_delay=1e-12)
.model uno_d d_pullup(load=1e-12)
V1 n1 0 PULSE(0 5 1e-7 1e-12 1e-12 0.000002999999 0.000005999999999987999)
V2 n2 0 PULSE(0 5 2e-7 1e-12 1e-12 6.99999e-7 0.00000139999999999944)
V3 n3 0 PULSE(0 5 2.53e-7 1e-12 1e-12 3.49999e-7 7.0000000000021e-7)
AIN0 [n1] [d4] adc_0
AIN1 [n2] [d5] adc_0
AIN2 [n3] [d6] adc_0
*@generar lut u0 {"comunes":["d4","d5","d6"],"rebanadas":[{"entradas":[],"salidas":["d0","d1","d2","d3"]}],"tabla":[84,81,69,21,85,85,85,85],"retardos":[[1.1999999999999998e-8,2.1999999999999995e-8],[1.1999999999999998e-8,2.1999999999999995e-8],[1.1999999999999998e-8,2.1999999999999995e-8],[1.1999999999999998e-8,2.1999999999999995e-8]]}
.options reltol=1e-4 abstol=1e-12 vntol=1e-7 xtrtol=7
.control
set wr_singlescale
set wr_vecnames
option numdgt=7
tran 1n 12000n 0 0.1n uic
wrdata salida.txt v(n1)
eprint d0 d1 d2 d3 > eventos.txt
.endc
.end
