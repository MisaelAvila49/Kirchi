* Autopolarizacion de un JFET J175 de canal P con resistencia en la fuente
.model JJ175 PJF(VTO=-4.5 BETA=0.00101204 LAMBDA=0 IS=1e-14 N=1 PB=1 CGS=1.6734e-11 CGD=1.3266e-11 RD=0 RS=0)
V1 1 0 DC 15
RG 2 0 1Meg
RS 1 3 100
RD 4 0 220
J1 4 2 3 JJ175
.options reltol=1e-4 abstol=1e-12 vntol=1e-7
.control
set wr_singlescale
set wr_vecnames
option numdgt=7
op
wrdata salida.txt v(3) v(4) i(v1)
.endc
.end
