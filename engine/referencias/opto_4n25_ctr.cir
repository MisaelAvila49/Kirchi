* 4N25 con 5 V y 330 ohm en el LED y 10 V con 1 kohm en el colector: CTR de 50 %
.include modelos.lib
V1 vin 0 DC 5
R1 vin a 330
V2 vcc 0 DC 10
RL vcc c 1k
D1 a x DOPT4
VF1 x 0 0
F1 c b VF1 0.0024876
Q1 c b 0 QOPT4
.options reltol=1e-4 abstol=1e-12 vntol=1e-7
.control
set wr_singlescale
set wr_vecnames
option numdgt=7
op
wrdata salida.txt v(a) v(c) i(v1) i(v2)
.endc
.end
