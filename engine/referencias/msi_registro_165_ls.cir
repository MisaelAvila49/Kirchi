* Registro 74LS165 a 5 V con carga por nivel, CLK INH, SER y los ocho datos al azar
.model adc_0 adc_bridge(in_low=0.8 in_high=2 rise_delay=1e-12 fall_delay=1e-12)
V1 n1 0 PWL(0 0 8.5e-7 0 8.500001e-7 5 0.00000297 5 0.0000029700001000000003 0 0.00000785 0 0.000007850000100000001 5 0.00001091 5 0.000010910000099999999 0 0.00001185 0 0.0000118500001 5 0.00001385 5 0.0000138500001 0 0.00001491 0 0.0000149100001 5 0.00001885 5 0.000018850000100000002 0 0.00002197 0 0.0000219700001 5 0.00002585 5 0.0000258500001 0 0.00002685 0 0.0000268500001 5 0.00002785 5 0.0000278500001 0 0.00002885 0 0.0000288500001 5 0.00002991 5 0.0000299100001 0)
V2 n2 0 PWL(0 0 0.00000185 0 0.0000018500001 5 0.00000991 5 0.0000099100001 0 0.00001397 0 0.0000139700001 5)
V3 n3 0 PWL(0 0 0.00000497 0 0.0000049700001 5 0.00000591 5 0.0000059100001 0 0.00000997 0 0.0000099700001 5 0.00002285 5 0.0000228500001 0 0.00002891 0 0.0000289100001 5 0.00002985 5 0.000029850000100000002 0)
V4 n4 0 PWL(0 0 3e-7 0 3.000001e-7 5 8e-7 5 8.000001e-7 0 0.0000013 0 0.0000013000001 5 0.0000018 5 0.0000018000001 0 0.0000023 0 0.0000023000001000000004 5 0.0000028 5 0.0000028000001000000002 0 0.0000033 0 0.0000033000001 5 0.0000038 5 0.0000038000001000000004 0 0.0000043 0 0.0000043000001 5 0.0000048 5 0.0000048000001000000006 0 0.0000053 0 0.0000053000001 5 0.0000058 5 0.0000058000001 0 0.0000063 0 0.000006300000100000001 5 0.0000068 5 0.0000068000001 0 0.0000073 0 0.0000073000001 5 0.0000078 5 0.0000078000001 0 0.0000083 0 0.0000083000001 5 0.0000088 5 0.000008800000099999999 0 0.0000093 0 0.000009300000099999999 5 0.0000098 5 0.0000098000001 0 0.0000103 0 0.0000103000001 5 0.0000108 5 0.0000108000001 0 0.0000113 0 0.000011300000099999998 5 0.0000118 5 0.000011800000099999999 0 0.0000123 0 0.000012300000099999999 5 0.0000128 5 0.0000128000001 0 0.0000133 0 0.0000133000001 5 0.0000138 5 0.0000138000001 0 0.0000143 0 0.000014300000099999999 5 0.0000148 5 0.000014800000099999999 0 0.0000153 0 0.0000153000001 5 0.0000158 5 0.0000158000001 0 0.0000163 0 0.000016300000099999998 5 0.0000168 5 0.0000168000001 0 0.0000173 0 0.000017300000100000002 5 0.0000178 5 0.0000178000001 0 0.0000183 0 0.000018300000100000003 5 0.0000188 5 0.0000188000001 0 0.0000193 0 0.0000193000001 5 0.0000198 5 0.000019800000100000002 0 0.0000203 0 0.0000203000001 5 0.0000208 5 0.000020800000100000002 0 0.0000213 0 0.0000213000001 5 0.0000218 5 0.0000218000001 0 0.0000223 0 0.0000223000001 5 0.0000228 5 0.0000228000001 0 0.0000233 0 0.000023300000100000002 5 0.0000238 5 0.0000238000001 0 0.0000243 0 0.000024300000100000003 5 0.0000248 5 0.0000248000001 0 0.0000253 0 0.0000253000001 5 0.0000258 5 0.000025800000100000002 0 0.0000263 0 0.0000263000001 5 0.0000268 5 0.000026800000100000003 0 0.0000273 0 0.0000273000001 5 0.0000278 5 0.0000278000001 0 0.0000283 0 0.000028300000100000002 5 0.0000288 5 0.0000288000001 0 0.0000293 0 0.000029300000100000002 5 0.0000298 5 0.0000298000001 0 0.0000303 0 0.0000303000001 5 0.0000308 5 0.0000308000001 0 0.0000313 0 0.0000313000001 5 0.0000318 5 0.0000318000001 0)
V5 n5 0 PWL(0 5 8.5e-7 5 8.500001e-7 0 0.00000491 0 0.0000049100001 5 0.00000897 5 0.000008970000099999999 0 0.00000985 0 0.000009850000099999999 5 0.00001191 5 0.0000119100001 0 0.00001391 0 0.000013910000099999999 5 0.00001485 5 0.0000148500001 0 0.00001591 0 0.0000159100001 5 0.00001791 5 0.0000179100001 0 0.00002185 0 0.0000218500001 5 0.00002291 5 0.0000229100001 0 0.00002791 0 0.0000279100001 5 0.00003091 5 0.0000309100001 0)
V6 n6 0 PWL(0 5 9.7e-7 5 9.700001e-7 0 0.00000385 0 0.0000038500001 5 0.00000697 5 0.0000069700001 0 0.00001097 0 0.0000109700001 5 0.00001797 5 0.0000179700001 0)
V7 n7 0 PWL(0 0 0.00000691 0 0.0000069100001 5 0.00000885 5 0.0000088500001 0 0.00001297 0 0.0000129700001 5 0.00001991 5 0.000019910000100000002 0 0.00002097 0 0.000020970000100000002 5 0.00002191 5 0.0000219100001 0 0.00002491 0 0.000024910000100000002 5 0.00002797 5 0.0000279700001 0)
V8 n8 0 PWL(0 5 9.1e-7 5 9.100001e-7 0 0.00000291 0 0.0000029100001 5 0.00001197 5 0.000011970000099999999 0 0.00001697 0 0.0000169700001 5 0.00002091 5 0.0000209100001 0 0.00002397 0 0.0000239700001 5 0.00002485 5 0.000024850000100000003 0)
V9 n9 0 PWL(0 0 0.00000191 0 0.0000019100001 5 0.00000391 5 0.000003910000100000001 0 0.00000485 0 0.0000048500001 5 0.00000597 5 0.0000059700001 0 0.00000791 0 0.0000079100001 5 0.00001085 5 0.0000108500001 0 0.00001291 0 0.0000129100001 5 0.00002391 5 0.0000239100001 0 0.00002591 0 0.000025910000100000003 5 0.00002697 5 0.000026970000100000003 0)
V10 n10 0 PWL(0 5 0.00000797 5 0.0000079700001 0 0.00000891 0 0.0000089100001 5 0.00002385 5 0.000023850000100000002 0 0.00002691 0 0.0000269100001 5)
V11 n11 0 PWL(0 0 0.00000285 0 0.0000028500001 5 0.00000585 5 0.0000058500001 0 0.00000685 0 0.0000068500001 5 0.00001285 5 0.000012850000099999999 0 0.00001685 0 0.0000168500001 5 0.00001785 5 0.000017850000100000002 0 0.00003097 0 0.0000309700001 5)
V12 n12 0 PWL(0 5 0.00001497 5 0.000014970000099999999 0 0.00001585 0 0.0000158500001 5 0.00001691 5 0.0000169100001 0 0.00001985 0 0.0000198500001 5 0.00002085 5 0.0000208500001 0 0.00002297 0 0.0000229700001 5 0.00002997 5 0.0000299700001 0 0.00003085 0 0.0000308500001 5)
AIN0 [n4] [d2] adc_0
AIN1 [n2] [d3] adc_0
AIN2 [n5] [d4] adc_0
AIN3 [n1] [d5] adc_0
AIN4 [n6] [d6] adc_0
AIN5 [n7] [d7] adc_0
AIN6 [n8] [d8] adc_0
AIN7 [n9] [d9] adc_0
AIN8 [n10] [d10] adc_0
AIN9 [n11] [d11] adc_0
AIN10 [n12] [d12] adc_0
AIN11 [n3] [d13] adc_0
*@generar msi u0 {"entradas":["d2","d3","d4","d5","d6","d7","d8","d9","d10","d11","d12","d13"],"salidas":["d0","d1"],"nucleo":{"tipo":"desplazamiento","bits":8,"reloj":{"senales":[{"entrada":0},{"entrada":1}],"combina":"O","flanco":"subida"},"serie":[{"entrada":2}],"carga":{"senal":{"entrada":3,"bajo":true},"sincrona":false,"datos":[4,5,6,7,8,9,10,11]}},"de":[{"tipo":"directa","fuente":{"bit":7}},{"tipo":"directa","fuente":{"bit":7},"negada":true}],"retardos":[[8.000000000000002e-9,1.3e-8],[8.000000000000002e-9,1.3e-8]]}
.options reltol=1e-4 abstol=1e-12 vntol=1e-7 xtrtol=7
.control
set wr_singlescale
set wr_vecnames
option numdgt=7
tran 1n 32000n 0 0.1n uic
wrdata salida.txt v(n1)
eprint d0 d1 > eventos.txt
.endc
.end
