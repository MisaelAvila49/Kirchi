* Divisor de 5 V con 10 kOhm y el NTC de 10 kOhm de Vishay a 100 C (tabla R/T)
*@generar termistor tm1 {"tipo":"ntc","r25":10000,"beta":3977,"rt":[[-40,332094],[-35,239900],[-30,175200],[-25,129287],[-20,96358],[-15,72500],[-10,55046],[-5,42157],[0,32554],[5,25339],[10,19872],[15,15698],[20,12488],[25,10000],[30,8059],[35,6535],[40,5330],[45,4372],[50,3605],[55,2989],[60,2490],[65,2084],[70,1753],[75,1481],[80,1256],[85,1070],[90,915.4],[95,786],[100,677.3],[105,585.7],[110,508.3],[115,442.6],[120,386.6],[125,338.7],[130,297.7],[135,262.4],[140,231.9],[145,205.5],[150,182.6]],"delta":0.007,"tau":15}
V1 1 0 DC 5
R1 1 2 10k
X1 2 0 tm1 amb=100
.options reltol=1e-4 abstol=1e-12 vntol=1e-7
.control
set wr_singlescale
set wr_vecnames
option numdgt=7
op
wrdata salida.txt v(2) i(v1)
.endc
.end
