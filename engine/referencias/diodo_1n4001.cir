* Diodo 1N4001 a unos 1 A (corriente de prueba de VFM)
.include modelos.lib
V1 1 0 DC 5
R1 1 2 4.1
D1 2 0 D1N4001
.options reltol=1e-4 abstol=1e-12 vntol=1e-7
.control
set wr_singlescale
set wr_vecnames
option numdgt=7
op
wrdata salida.txt v(2) i(v1)
.endc
.end
