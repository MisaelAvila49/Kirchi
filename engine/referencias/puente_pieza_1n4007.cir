* Puente rectificador de la pieza (cuatro 1N4007) con fuente flotante de 12 V y 50 Hz, filtro de 100u y carga de 1 k
.include modelos.lib
V1 1 2 SIN(0 12 50)
D1 1 3 D1N4007
D2 2 3 D1N4007
D3 0 1 D1N4007
D4 0 2 D1N4007
C1 3 0 100u
R1 3 0 1k
.options reltol=1e-4 abstol=1e-12 vntol=1e-7
.control
set wr_singlescale
set wr_vecnames
option numdgt=7
tran 50u 100m 0 5u uic
wrdata salida.txt v(3) i(v1)
.endc
.end
