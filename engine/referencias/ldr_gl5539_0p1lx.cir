* Divisor de 5 V con 10 kOhm y la fotorresistencia GL5539 a 0.1 lx
*@generar ldr ld1 {"r10":70711,"gamma":0.8,"roscuro":5000000,"tau_sube":0.02,"tau_baja":0.03}
V1 1 0 DC 5
R1 1 2 10k
X1 2 0 ld1 lux=0.1
.options reltol=1e-4 abstol=1e-12 vntol=1e-7
.control
set wr_singlescale
set wr_vecnames
option numdgt=7
op
wrdata salida.txt v(2) i(v1)
.endc
.end
