* LM317 con 12 V de entrada, R1 = 240 ohm, R2 = 720 ohm, carga de 100 ohm y 10 uF: referencia de 1.25 V entre salida y ajuste
.include modelos.lib
V1 in 0 DC 12
XU1 ref fb g in adj AMPOP a0=20000 gbw=1000000 sr=300000 rin=1000000000 rout=20 ilim=0.00082 dhi=0.77 dlo=0.1 rq=1000000000000
VREF ref0 adj DC 1.25
RSS ref0 ref 20000
CSS ref adj 1e-9
R1 out fb 50000
RF g nx 10000
CF nx fb 1e-7
I1 in adj DC 0.00005
RQ in out 2857
Q1 in g out QREGN
RA1 out adj 240
RA2 adj 0 720
RL out 0 100
C1 out 0 10u
.options reltol=1e-4 abstol=1e-12 vntol=1e-7
.control
set wr_singlescale
set wr_vecnames
option numdgt=7
tran 20u 12m 0 10u uic
wrdata salida.txt v(out) i(v1)
.endc
.end
