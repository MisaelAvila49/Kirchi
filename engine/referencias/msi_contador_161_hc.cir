* Contador 74HC161 a 4.5 V con carga, borrado asincrono y habilitaciones al azar
.model adc_0 adc_bridge(in_low=1.3499999999999999 in_high=3.15 rise_delay=1e-12 fall_delay=1e-12)
V1 n1 0 PWL(0 0 3e-7 0 3.000001e-7 4.5 8e-7 4.5 8.000001e-7 0 0.0000013 0 0.0000013000001 4.5 0.0000018 4.5 0.0000018000001 0 0.0000023 0 0.0000023000001000000004 4.5 0.0000028 4.5 0.0000028000001000000002 0 0.0000033 0 0.0000033000001 4.5 0.0000038 4.5 0.0000038000001000000004 0 0.0000043 0 0.0000043000001 4.5 0.0000048 4.5 0.0000048000001000000006 0 0.0000053 0 0.0000053000001 4.5 0.0000058 4.5 0.0000058000001 0 0.0000063 0 0.000006300000100000001 4.5 0.0000068 4.5 0.0000068000001 0 0.0000073 0 0.0000073000001 4.5 0.0000078 4.5 0.0000078000001 0 0.0000083 0 0.0000083000001 4.5 0.0000088 4.5 0.000008800000099999999 0 0.0000093 0 0.000009300000099999999 4.5 0.0000098 4.5 0.0000098000001 0 0.0000103 0 0.0000103000001 4.5 0.0000108 4.5 0.0000108000001 0 0.0000113 0 0.000011300000099999998 4.5 0.0000118 4.5 0.000011800000099999999 0 0.0000123 0 0.000012300000099999999 4.5 0.0000128 4.5 0.0000128000001 0 0.0000133 0 0.0000133000001 4.5 0.0000138 4.5 0.0000138000001 0 0.0000143 0 0.000014300000099999999 4.5 0.0000148 4.5 0.000014800000099999999 0 0.0000153 0 0.0000153000001 4.5 0.0000158 4.5 0.0000158000001 0 0.0000163 0 0.000016300000099999998 4.5 0.0000168 4.5 0.0000168000001 0 0.0000173 0 0.000017300000100000002 4.5 0.0000178 4.5 0.0000178000001 0 0.0000183 0 0.000018300000100000003 4.5 0.0000188 4.5 0.0000188000001 0 0.0000193 0 0.0000193000001 4.5 0.0000198 4.5 0.000019800000100000002 0 0.0000203 0 0.0000203000001 4.5 0.0000208 4.5 0.000020800000100000002 0 0.0000213 0 0.0000213000001 4.5 0.0000218 4.5 0.0000218000001 0 0.0000223 0 0.0000223000001 4.5 0.0000228 4.5 0.0000228000001 0 0.0000233 0 0.000023300000100000002 4.5 0.0000238 4.5 0.0000238000001 0 0.0000243 0 0.000024300000100000003 4.5 0.0000248 4.5 0.0000248000001 0 0.0000253 0 0.0000253000001 4.5 0.0000258 4.5 0.000025800000100000002 0 0.0000263 0 0.0000263000001 4.5 0.0000268 4.5 0.000026800000100000003 0 0.0000273 0 0.0000273000001 4.5 0.0000278 4.5 0.0000278000001 0 0.0000283 0 0.000028300000100000002 4.5 0.0000288 4.5 0.0000288000001 0 0.0000293 0 0.000029300000100000002 4.5 0.0000298 4.5 0.0000298000001 0 0.0000303 0 0.0000303000001 4.5 0.0000308 4.5 0.0000308000001 0 0.0000313 0 0.0000313000001 4.5 0.0000318 4.5 0.0000318000001 0 0.0000323 0 0.000032300000100000004 4.5 0.0000328 4.5 0.000032800000099999996 0 0.0000333 0 0.000033300000099999995 4.5 0.0000338 4.5 0.0000338000001 0 0.0000343 0 0.0000343000001 4.5 0.0000348 4.5 0.0000348000001 0 0.0000353 0 0.000035300000099999996 4.5 0.0000358 4.5 0.000035800000099999994 0 0.0000363 0 0.0000363000001 4.5 0.0000368 4.5 0.0000368000001 0 0.0000373 0 0.0000373000001 4.5 0.0000378 4.5 0.000037800000099999995 0 0.0000383 0 0.0000383000001 4.5 0.0000388 4.5 0.0000388000001 0 0.0000393 0 0.0000393000001 4.5 0.0000398 4.5 0.0000398000001 0 0.0000403 0 0.000040300000099999995 4.5 0.0000408 4.5 0.0000408000001 0 0.0000413 0 0.0000413000001 4.5 0.0000418 4.5 0.0000418000001 0 0.0000423 0 0.000042300000099999996 4.5 0.0000428 4.5 0.000042800000099999995 0 0.0000433 0 0.0000433000001 4.5 0.0000438 4.5 0.0000438000001 0 0.0000443 0 0.0000443000001 4.5 0.0000448 4.5 0.000044800000099999996 0 0.0000453 0 0.000045300000099999995 4.5 0.0000458 4.5 0.0000458000001 0 0.0000463 0 0.0000463000001 4.5 0.0000468 4.5 0.0000468000001 0 0.0000473 0 0.000047300000099999996 4.5 0.0000478 4.5 0.000047800000099999995 0 0.0000483 0 0.0000483000001 4.5 0.0000488 4.5 0.0000488000001 0 0.0000493 0 0.0000493000001 4.5 0.0000498 4.5 0.000049800000099999996 0 0.0000503 0 0.000050300000099999994 4.5 0.0000508 4.5 0.0000508000001 0 0.0000513 0 0.0000513000001 4.5 0.0000518 4.5 0.0000518000001 0 0.0000523 0 0.000052300000099999996 4.5 0.0000528 4.5 0.000052800000099999994 0 0.0000533 0 0.0000533000001 4.5 0.0000538 4.5 0.0000538000001 0 0.0000543 0 0.0000543000001 4.5 0.0000548 4.5 0.000054800000099999995 0 0.0000553 0 0.0000553000001 4.5 0.0000558 4.5 0.0000558000001 0 0.0000563 0 0.0000563000001 4.5 0.0000568 4.5 0.000056800000099999997 0 0.0000573 0 0.000057300000099999995 4.5 0.0000578 4.5 0.0000578000001 0 0.0000583 0 0.0000583000001 4.5 0.0000588 4.5 0.0000588000001 0 0.0000593 0 0.000059300000099999996 4.5 0.0000598 4.5 0.000059800000099999995 0)
V2 n2 0 PWL(0 4.5 0.00000145 4.5 0.0000014500001 0 0.0000016 0 0.0000016000001 4.5 0.00005545 4.5 0.0000554500001 0 0.0000556 0 0.000055600000099999994 4.5 0.00005945 4.5 0.0000594500001 0 0.0000596 0 0.0000596000001 4.5)
V3 n3 0 PWL(0 4.5 5e-8 4.5 5.00001e-8 0 0.00000105 0 0.0000010500001 4.5 0.00000305 4.5 0.0000030500001000000004 0 0.00000405 0 0.0000040500001 4.5 0.00001205 4.5 0.0000120500001 0 0.00001305 0 0.000013050000099999999 4.5 0.00003405 4.5 0.0000340500001 0 0.00003505 0 0.000035050000099999996 4.5 0.00005805 4.5 0.0000580500001 0 0.00005905 0 0.0000590500001 4.5)
V4 n4 0 PWL(0 4.5 0.00000205 4.5 0.0000020500001000000002 0 0.00000305 0 0.0000030500001000000004 4.5 0.00000505 4.5 0.0000050500001 0 0.00000605 0 0.0000060500001000000005 4.5 0.00002705 4.5 0.000027050000100000002 0 0.00002805 0 0.000028050000100000002 4.5 0.00003305 4.5 0.000033050000099999995 0 0.00003405 0 0.0000340500001 4.5 0.00004505 4.5 0.000045050000099999996 0 0.00004705 0 0.0000470500001 4.5 0.00005005 4.5 0.000050050000099999995 0 0.00005105 0 0.0000510500001 4.5 0.00005205 4.5 0.000052050000099999996 0 0.00005305 0 0.0000530500001 4.5)
V5 n5 0 PWL(0 4.5 0.00000205 4.5 0.0000020500001000000002 0 0.00000305 0 0.0000030500001000000004 4.5 0.00001205 4.5 0.0000120500001 0 0.00001305 0 0.000013050000099999999 4.5 0.00001505 4.5 0.0000150500001 0 0.00001605 0 0.0000160500001 4.5 0.00003405 4.5 0.0000340500001 0 0.00003505 0 0.000035050000099999996 4.5 0.00004005 4.5 0.000040050000099999996 0 0.00004205 0 0.0000420500001 4.5 0.00005705 4.5 0.000057050000099999996 0 0.00005805 0 0.0000580500001 4.5 0.00005905 4.5 0.0000590500001 0)
V6 n6 0 PWL(0 0 1e-7 0 1.000001e-7 4.5 0.0000011 4.5 0.0000011000001 0 0.0000081 0 0.0000081000001 4.5 0.0000091 4.5 0.0000091000001 0 0.0000151 0 0.0000151000001 4.5 0.0000191 4.5 0.000019100000100000002 0 0.0000221 0 0.0000221000001 4.5 0.0000251 4.5 0.000025100000100000002 0 0.0000311 0 0.0000311000001 4.5 0.0000321 4.5 0.0000321000001 0 0.0000371 0 0.0000371000001 4.5 0.0000401 4.5 0.0000401000001 0 0.0000411 0 0.000041100000099999994 4.5 0.0000461 4.5 0.0000461000001 0 0.0000491 0 0.0000491000001 4.5 0.0000501 4.5 0.000050100000099999996 0 0.0000551 0 0.000055100000099999996 4.5)
V7 n7 0 PWL(0 0 0.0000011 0 0.0000011000001 4.5 0.0000021 4.5 0.0000021000001 0 0.0000041 0 0.0000041000001000000005 4.5 0.0000091 4.5 0.0000091000001 0 0.0000101 0 0.0000101000001 4.5 0.0000131 4.5 0.0000131000001 0 0.0000151 0 0.0000151000001 4.5 0.0000191 4.5 0.000019100000100000002 0 0.0000211 0 0.0000211000001 4.5 0.0000231 4.5 0.0000231000001 0 0.0000301 0 0.0000301000001 4.5 0.0000341 4.5 0.0000341000001 0 0.0000351 0 0.0000351000001 4.5 0.0000371 4.5 0.0000371000001 0 0.0000381 0 0.000038100000099999996 4.5 0.0000421 4.5 0.0000421000001 0 0.0000431 0 0.000043100000099999996 4.5 0.0000451 4.5 0.0000451000001 0 0.0000471 0 0.0000471000001 4.5 0.0000501 4.5 0.000050100000099999996 0 0.0000511 0 0.0000511000001 4.5 0.0000581 4.5 0.000058100000099999994 0)
V8 n8 0 PWL(0 0 0.0000011 0 0.0000011000001 4.5 0.0000041 4.5 0.0000041000001000000005 0 0.0000051 0 0.0000051000001 4.5 0.0000061 4.5 0.0000061000001 0 0.0000091 0 0.0000091000001 4.5 0.0000111 4.5 0.000011100000099999999 0 0.0000131 0 0.0000131000001 4.5 0.0000141 4.5 0.000014100000099999999 0 0.0000161 0 0.0000161000001 4.5 0.0000201 4.5 0.000020100000100000002 0 0.0000221 0 0.0000221000001 4.5 0.0000251 4.5 0.000025100000100000002 0 0.0000361 0 0.000036100000099999995 4.5 0.0000371 4.5 0.0000371000001 0 0.0000421 0 0.0000421000001 4.5 0.0000461 4.5 0.0000461000001 0 0.0000481 0 0.000048100000099999995 4.5 0.0000491 4.5 0.0000491000001 0 0.0000531 0 0.000053100000099999995 4.5 0.0000571 4.5 0.0000571000001 0)
V9 n9 0 PWL(0 0 0.0000011 0 0.0000011000001 4.5 0.0000061 4.5 0.0000061000001 0 0.0000081 0 0.0000081000001 4.5 0.0000121 4.5 0.0000121000001 0 0.0000131 0 0.0000131000001 4.5 0.0000171 4.5 0.0000171000001 0 0.0000221 0 0.0000221000001 4.5 0.0000301 4.5 0.0000301000001 0 0.0000321 0 0.0000321000001 4.5 0.0000411 4.5 0.000041100000099999994 0 0.0000441 0 0.0000441000001 4.5 0.0000461 4.5 0.0000461000001 0 0.0000481 0 0.000048100000099999995 4.5 0.0000501 4.5 0.000050100000099999996 0 0.0000511 0 0.0000511000001 4.5 0.0000531 4.5 0.000053100000099999995 0 0.0000541 0 0.0000541000001 4.5 0.0000551 4.5 0.000055100000099999996 0)
AIN0 [n1] [d5] adc_0
AIN1 [n4] [d6] adc_0
AIN2 [n5] [d7] adc_0
AIN3 [n2] [d8] adc_0
AIN4 [n3] [d9] adc_0
AIN5 [n6] [d10] adc_0
AIN6 [n7] [d11] adc_0
AIN7 [n8] [d12] adc_0
AIN8 [n9] [d13] adc_0
*@generar msi u0 {"entradas":["d5","d6","d7","d8","d9","d10","d11","d12","d13"],"salidas":["d0","d1","d2","d3","d4"],"nucleo":{"tipo":"contador","bits":4,"modulo":16,"reloj":{"senales":[{"entrada":0}],"flanco":"subida"},"habilita":[{"entrada":1},{"entrada":2}],"borra":{"senal":{"entrada":3,"bajo":true},"sincrona":false},"carga":{"senal":{"entrada":4,"bajo":true},"sincrona":true,"datos":[5,6,7,8]}},"de":[{"tipo":"directa","fuente":{"bit":0}},{"tipo":"directa","fuente":{"bit":1}},{"tipo":"directa","fuente":{"bit":2}},{"tipo":"directa","fuente":{"bit":3}},{"tipo":"tabla","columna":0}],"fuentes":[{"entrada":2},{"bit":3},{"bit":2},{"bit":1},{"bit":0}],"tabla":[0,0,0,0,0,0,0,0,0,0,0,0,0,0,0,0,0,0,0,0,0,0,0,0,0,0,0,0,0,0,0,1],"retardos":[[2.1499999999999994e-8,2.1499999999999994e-8],[2.1499999999999994e-8,2.1499999999999994e-8],[2.1499999999999994e-8,2.1499999999999994e-8],[2.1499999999999994e-8,2.1499999999999994e-8],[2.0499999999999998e-8,2.0499999999999998e-8]]}
.options reltol=1e-4 abstol=1e-12 vntol=1e-7 xtrtol=7
.control
set wr_singlescale
set wr_vecnames
option numdgt=7
tran 1n 60000n 0 0.1n uic
wrdata salida.txt v(n1)
eprint d0 d1 d2 d3 d4 > eventos.txt
.endc
.end
