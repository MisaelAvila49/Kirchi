* Divisor de 5 V con 1 kOhm y la PTC cuyo ambiente sube de 25 a 125 C entre 2 y 4 ms y baja a -20 C entre 6 y 8 ms
*@generar termistor tm1 {"tipo":"ptc","r25":2210,"beta":557,"rt":[[-20,3600],[0,2890],[10,2590],[20,2330],[25,2210],[30,2100],[40,1900],[50,1740],[60,1590],[70,1480],[80,1410],[90,1450],[100,1620],[105,1780],[110,2040],[115,2500],[120,3470],[125,5470],[130,10500],[135,28600],[140,93700],[145,376000],[150,1460000],[155,5420000],[160,16400000],[165,40300000],[170,85700000],[175,126000000],[180,156000000],[190,184000000],[200,172000000],[210,144000000],[220,112000000]],"delta":0.0046,"tau":40,"ambNodo":true}
V1 1 0 DC 5
R1 1 2 1k
VA amb 0 PWL(0 25 2m 25 4m 125 6m 125 8m -20 10m -20)
X1 2 0 amb tm1
.options reltol=1e-4 abstol=1e-12 vntol=1e-7
.control
set wr_singlescale
set wr_vecnames
option numdgt=7
tran 5u 10m 0 5u uic
wrdata salida.txt v(2) i(v1)
.endc
.end
