* Fuente de corriente de pulso de 1 mA (400 us de ancho, flancos de 10 us, cada 1 ms) sobre 1 kohm y 1 uF
I1 0 1 PULSE(0 1m 0 10u 10u 400u 1m)
R1 1 0 1k
C1 1 0 1u
.options reltol=1e-4 abstol=1e-12 vntol=1e-7
.control
set wr_singlescale
set wr_vecnames
option numdgt=7
tran 2u 5m 0 2u uic
wrdata salida.txt v(1)
.endc
.end
