* spice-rc
Vp ent 0 PULSE(0 5 1m 10u 10u 4m 10m)
R1 ent sal 1k
C1 sal 0 1u
.options reltol=1e-4 abstol=1e-12 vntol=1e-7
.control
set wr_singlescale
set wr_vecnames
option numdgt=7
tran 10u 30m
wrdata salida.txt v(ent) v(sal)
.endc
.end
