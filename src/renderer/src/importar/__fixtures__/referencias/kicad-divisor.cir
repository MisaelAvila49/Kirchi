* kicad-divisor
V1 in 0 DC 10
R1 in out 10k
R2 out 0 4.7k
.options reltol=1e-4 abstol=1e-12 vntol=1e-7
.control
set wr_singlescale
set wr_vecnames
option numdgt=7
op
wrdata salida.txt v(in) v(out)
.endc
.end
