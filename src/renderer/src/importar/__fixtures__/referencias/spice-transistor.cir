* spice-transistor
Vcc vcc 0 DC 12
Vb b1 0 DC 0.7
Rc vcc c 2.2k
Re e 0 470
Rb b1 b 1k
Q1 c b e 2N3904
* El importador lleva el .model del archivo al transistor.
.model 2N3904 NPN(IS=6.7f BF=416 VAF=74 CJE=4.5p)
.options reltol=1e-4 abstol=1e-12 vntol=1e-7
.control
set wr_singlescale
set wr_vecnames
option numdgt=7
op
wrdata salida.txt v(c) v(b) v(e)
.endc
.end
