* ltspice-npn
V1 vcc 0 DC 12
V2 vb 0 DC 0.7
RC vcc c 2.2k
RB vb b 100k
Q1 c b 0 2N3904
* El importador lleva el .model del archivo al transistor.
.model 2N3904 NPN(IS=6.7f BF=416 VAF=74)
.options reltol=1e-4 abstol=1e-12 vntol=1e-7
.control
set wr_singlescale
set wr_vecnames
option numdgt=7
op
wrdata salida.txt v(c) v(b)
.endc
.end
