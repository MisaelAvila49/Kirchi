* ltspice-divisor
V1 n1 0 DC 12
R1 n1 out 10k
R2 out 0 4.7k
.options reltol=1e-4 abstol=1e-12 vntol=1e-7
.control
set wr_singlescale
set wr_vecnames
option numdgt=7
op
wrdata salida.txt v(n1) v(out)
.endc
.end
